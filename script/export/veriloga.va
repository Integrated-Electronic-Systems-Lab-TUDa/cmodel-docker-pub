// VerilogA implementation for RFET_Model
// using Expressions describing a Neural Network.
// The NN is trained on a TCAD Dataset describing the RFET Charateristics

`include "constants.vams"
`include "disciplines.vams"

module diss_pRFET_model(lat1, lat2, FG, TG, BG );

inout lat1, lat2, FG, TG, BG ;
electrical lat1, lat2, FG, TG, BG;

 // PARAMETERS
// --- HiddenLayer1 ---
real  W00[0:33] = {8.608351946e-01, 1.739983857e-01, -1.359618902e+00, -4.060085118e-01, -5.255632997e-01, -7.936388254e-03, 9.928059578e-01, 1.986447722e-01, 4.457964003e-01, 2.792751491e-01, -3.776752055e-01, -1.497015953e-01, 5.542032719e-01, -5.495696068e-01, -6.824151278e-01, -1.411472410e-01, 1.107697248e+00, -7.238937914e-02, 4.546707571e-01, 7.926687002e-01, 4.110627770e-01, -1.848477125e-01, -4.508157372e-01, 2.009969354e-01, -4.921118021e-01, 1.582983494e+00, 4.398989081e-01, -1.523816943e+00, 2.750027776e-01, 6.018133163e-01, 2.922066152e-01, -2.681078017e-01, -2.219674587e+00, 2.735594213e-01};
real  W01[0:33] = {-1.089197516e+00, -1.639759690e-01, -5.749203563e-01, 2.825716138e-01, 8.089888692e-01, -3.985244930e-01, -1.408266902e+00, -1.985909641e-01, 5.147851631e-02, 7.116927207e-02, 2.587265372e-01, -2.201318741e-01, -5.977374911e-01, -1.019559875e-01, -1.324198604e+00, 1.019769385e-01, 4.271498322e-01, 1.309727430e+00, 2.271786928e-01, 1.864916533e-01, -3.063932657e-01, 8.914033882e-03, 8.991529047e-02, -9.545359761e-03, -8.805653453e-02, 1.447447538e-01, -3.755440116e-01, 7.603068948e-01, -3.920095563e-01, -9.839178622e-02, 2.751416862e-01, 3.026782870e-01, -2.204055488e-01, 1.460016221e-01};
real  W02[0:33] = {9.451174736e-01, -2.823067643e-02, 4.171828628e-01, 2.373898476e-01, 1.800931990e-02, -1.292201430e-01, -1.302912086e-01, -5.841174126e-01, 2.728268132e-02, 1.360758692e-01, 3.625771999e-01, -1.571802795e-01, -1.060493514e-01, -1.541616023e-01, 4.246774316e-01, 1.481357962e-01, -1.024483919e+00, -3.171633929e-02, 2.798164487e-01, -1.609750986e+00, 1.093371306e-02, 9.611925483e-01, 3.972612619e-01, 5.656047463e-01, -4.912119731e-02, 8.965711296e-02, -7.120835185e-01, -4.462360144e-01, -6.123193502e-01, 1.090003699e-01, 1.427586973e-01, 3.472902775e-01, -1.621642411e-01, 1.792698503e-01};

real  B0[0:33] = {5.243638158e-01, 1.806022823e-01, -2.047664076e-01, 8.997427672e-02, -1.139106825e-01, 3.734590709e-01, 3.433777392e-02, -4.538572207e-02, 3.077131808e-01, -2.710184157e-01, 3.743559420e-01, 3.470078111e-01, 1.200276837e-01, -5.327842832e-01, 4.278570712e-01, -1.180350222e-02, 1.224358082e-01, -6.293501705e-02, 4.494378865e-01, -1.903052479e-01, 1.752271205e-01, -5.924260616e-01, 4.958226532e-02, -8.874833584e-02, 3.319948614e-01, -1.954362094e-01, -6.592383236e-02, 1.789350808e-01, 4.287716746e-01, -6.113692746e-02, 2.415002286e-01, -4.228338003e-01, -7.654763013e-02, 1.480347961e-01};
// --- HiddenLayer2 ---
real  W10[0:33] = {2.284981012e-01, 4.039988518e-01, 3.456521779e-02, -1.327735782e-01, -1.052592248e-01, -1.056419730e+00, -2.107088417e-01, -8.992893100e-01, -3.317664862e-01, -5.525494218e-01, -7.089804858e-02, 6.503355503e-01, -3.768475950e-01, -2.288076431e-01, 2.663454413e-02, 6.566849351e-02, 6.851335764e-01, 2.875292599e-01, 7.375296950e-02, -8.581605554e-01, -7.124432325e-01, -6.611753702e-01, 1.980836540e-01, -7.843051106e-02, 4.868815839e-01, 1.322404623e+00, -5.417199135e-01, 8.492267132e-01, 4.581736624e-01, 4.174880683e-01, -3.451450169e-02, 9.207370281e-01, 2.528415620e-01, 6.701087356e-01};
real  W11[0:33] = {-2.561420798e-01, -8.136329800e-02, 2.668098211e-01, 1.366900504e-01, 1.990879886e-02, -1.383071095e-01, -3.652221262e-01, -3.915343583e-01, -2.609725669e-02, -1.982840598e-01, -3.514384627e-01, -2.166888267e-01, -6.699522138e-01, -3.985869698e-03, -2.026203461e-02, 3.724896908e-01, -5.856318474e-01, -3.348806798e-01, 8.671874553e-02, 1.185101196e-01, 3.725129366e-01, 9.955719858e-02, 1.798158586e-01, 2.338296026e-01, -3.075559139e-01, 1.361837536e-01, -3.154197633e-01, 5.702970549e-02, -6.246968359e-02, -4.939762354e-01, 2.384714782e-01, -2.200839520e-01, -2.064553350e-01, -4.189877808e-01};
real  W12[0:33] = {6.652649641e-01, -6.161814928e-01, -3.598907590e-01, 6.792448163e-01, -3.250946105e-01, 8.040283918e-01, 3.451253474e-01, 3.713439032e-02, -5.363849178e-02, 1.812056266e-02, 3.504311740e-01, -2.771811485e-01, -5.860871673e-01, 5.386349559e-01, 2.350280732e-01, 5.524238944e-01, -3.391210437e-01, -6.351352930e-01, -3.053114116e-01, 9.649119377e-01, 3.115519285e-01, 7.187992930e-01, 4.057944715e-01, -5.452487469e-01, -1.522826999e-01, -1.377709389e+00, -1.529187709e-01, -8.173930049e-01, -3.174280226e-01, -4.971208572e-01, 2.493083477e-01, 6.888538599e-01, -9.128453135e-01, 4.283430278e-01};
real  W13[0:33] = {-3.300843835e-01, -4.589091241e-01, 2.253013998e-01, 3.238143921e-01, -1.353477594e-02, 6.398880482e-02, 3.122059107e-01, -5.183056593e-01, 4.421131313e-01, 4.685425758e-01, 5.179948211e-01, -3.587307036e-01, 3.956249952e-01, -7.505688071e-02, -1.590358615e-01, 3.507166803e-01, -2.115487307e-02, 7.817613333e-02, 5.086101890e-01, 3.471025527e-01, -3.596783876e-01, -2.707565427e-01, -6.995355487e-01, 5.865796208e-01, 5.009972453e-01, -1.025023222e+00, 1.366150659e-02, 5.071390793e-02, -2.293391675e-01, -2.863584161e-01, 1.146052927e-01, 1.312254816e-01, -1.694409698e-01, 1.824355423e-01};
real  W14[0:33] = {-2.780174315e-01, -4.172495008e-01, 8.073589206e-02, 2.689110637e-01, 2.974648476e-01, 1.428924315e-02, 7.403984666e-02, 1.231200621e-01, 7.203912735e-01, -4.939349592e-01, 2.063816339e-01, 2.476927638e-02, 4.345158041e-01, 2.111112699e-02, 3.665160239e-01, -1.710914969e-01, -4.252638295e-02, 4.458791912e-01, -5.393775180e-02, 2.015825659e-01, -4.499397278e-01, -8.980311751e-01, -7.067151666e-01, 5.515968800e-01, -4.708086550e-01, -1.638706774e-02, 2.204886675e-01, 1.399394721e-01, 1.043176185e-02, 7.385460138e-01, 3.794676661e-01, 5.855505466e-01, -3.792691827e-01, -1.379117277e-02};
real  W15[0:33] = {-3.114165664e-01, -7.225785851e-01, 4.296886548e-02, -5.263754725e-02, -2.620669305e-01, 3.054517508e-01, -6.336210370e-01, -7.170185447e-02, -1.028162092e-01, -2.887583077e-01, 2.745234668e-01, -2.377115786e-01, -6.072600484e-01, 2.049942315e-02, -2.941943109e-01, 6.663147360e-02, -3.543136418e-01, -5.648583770e-01, 5.152527709e-03, 6.191071868e-01, 4.223313034e-01, 3.322203457e-01, 7.663691789e-02, -6.296033412e-02, -5.557651073e-02, -1.690605283e-01, -1.947706789e-01, -2.818364799e-01, -4.492950439e-01, -3.397522867e-01, 2.565566599e-01, 9.258916974e-02, -1.825097501e-01, 1.384630650e-01};
real  W16[0:33] = {-3.306669593e-01, 4.901160598e-01, 2.647931278e-01, -7.606790662e-01, -7.682851553e-01, -1.136412024e-01, 9.788151383e-01, 3.393751681e-01, -6.813641191e-01, 7.517269254e-01, -7.465552092e-01, -3.911771625e-02, -4.285176396e-01, -3.002859652e-01, -5.624873638e-01, -4.970404208e-01, 4.152749479e-01, -8.756842017e-01, -4.867359102e-01, -2.737239599e-01, 4.819433987e-01, 1.112883687e+00, 5.165742636e-01, -7.123229504e-01, 4.657281339e-01, -1.694779657e-02, 6.504193693e-02, -1.325329095e-01, 2.326695621e-01, -8.921925426e-01, -1.309104413e-01, -6.908261180e-01, 6.718180776e-01, -6.632253528e-01};
real  W17[0:33] = {-2.142733485e-01, -1.444568038e-01, -2.928924561e-01, -3.135164976e-01, 1.942881756e-02, -1.633488089e-01, -7.039952874e-01, 1.976625800e+00, 5.447208136e-02, -2.998495102e-01, 1.347035319e-01, 3.017696440e-01, -9.108468145e-02, 6.055677533e-01, 1.455985568e-02, -6.867252588e-01, -2.065765671e-02, 5.935921147e-02, -4.642766714e-01, -2.924361229e-01, 1.569907069e-01, 3.725024462e-01, 4.727271199e-01, -4.899551570e-01, 1.774560511e-01, 2.313201874e-01, 9.510032088e-02, -3.762853742e-01, 2.610172927e-01, 9.211239964e-02, -3.268783092e-01, -9.960673749e-02, 6.025711298e-01, 2.180306166e-01};
real  W18[0:33] = {-5.158812404e-01, -1.445029676e-01, 2.808780074e-01, -3.846435547e-01, -2.415215671e-01, 1.394855529e-01, -2.294055074e-01, -1.587898433e-01, 4.167851210e-01, -3.709083498e-01, -9.979769588e-01, -1.397231668e-01, -3.826757073e-01, 5.594114587e-02, -5.276545882e-01, 2.973719835e-01, -2.102886736e-01, 1.320499461e-02, -8.675085008e-02, 5.504174531e-02, 5.416088700e-01, 2.369325906e-01, 1.094872504e-01, 5.736697931e-03, -3.779184222e-01, 6.393295527e-01, -3.222317398e-01, -1.465809643e-01, -9.619668871e-02, -2.391511053e-01, 4.098338187e-01, -4.510570467e-01, 3.121305406e-01, -1.230234861e+00};
real  W19[0:33] = {5.081544518e-01, 5.257375240e-01, -2.031676024e-01, 5.033831596e-01, 3.440775573e-01, -1.318736821e-01, 4.322116449e-02, -1.491536498e-01, 7.422168739e-03, -1.229511052e-01, -4.544800818e-01, 3.517268002e-01, 3.038954176e-02, -1.668298393e-01, -3.252414614e-02, -4.224620759e-02, 3.215164542e-01, -5.945491046e-02, -3.563117683e-01, -2.223161161e-01, -6.073501706e-02, -1.409793049e-01, 3.472077474e-02, -1.702027470e-01, -2.167608887e-01, 5.626462102e-01, 2.003815174e-01, -2.957241535e-01, 3.292622268e-01, -1.077935658e-02, -2.643038929e-01, 2.004258335e-02, -2.182672471e-01, 1.054628342e-01};
real  W110[0:33] = {-2.228053361e-01, -7.942398787e-01, 1.247592047e-01, 3.296466172e-01, -1.874269992e-01, 1.016106606e-01, 4.770156741e-01, -8.876054287e-01, 2.439335138e-01, -1.284793857e-02, -2.114748396e-02, -4.610280693e-01, -5.327895656e-02, -6.597146392e-01, -4.145595059e-02, 6.121655107e-01, -2.529788315e-01, 1.726454794e-01, 4.815985262e-01, 1.854237020e-01, 7.286348194e-02, -4.250259101e-01, -6.819276214e-01, 3.527477682e-01, 1.415491402e-01, -8.120511174e-01, -5.793254375e-01, -7.815093547e-02, -8.889499903e-01, -5.028321147e-01, 7.446311712e-01, -5.114369467e-02, -6.008439064e-01, -9.309737384e-02};
real  W111[0:33] = {-8.161860704e-01, -6.431608796e-01, 3.915975690e-01, -4.480624497e-01, -5.073458552e-01, 4.220074713e-01, -6.320594549e-01, 2.166075818e-02, 3.508013487e-01, 1.438402385e-01, 2.438164651e-01, -9.120225161e-02, -3.080706000e-01, -6.008034572e-02, 1.499435157e-01, -8.706752956e-02, -3.795460165e-01, -1.093624085e-01, 3.987116516e-01, 3.706274629e-01, 1.255121082e-01, 3.921629190e-01, 2.957830131e-01, 2.475854009e-01, -1.319900155e-01, -6.688891649e-01, -1.739555150e-01, 9.128656238e-02, -4.430168271e-01, -3.521155417e-01, 3.107897341e-01, -1.501352489e-01, -3.011035919e-02, 1.690747142e-01};
real  W112[0:33] = {2.250795960e-01, -5.559066311e-02, 3.523999453e-01, -7.079037279e-02, -1.621747017e-01, 2.171716392e-01, 5.993396044e-02, -4.180353880e-01, -1.069368124e+00, -4.450641572e-02, -3.871987388e-02, -3.795097023e-02, -5.102730393e-01, 4.685224593e-02, 7.184106112e-02, -2.373126447e-01, -1.956277713e-02, -3.407060206e-01, -1.994064152e-01, 1.875230111e-03, 4.728266001e-01, 1.154758096e+00, 7.875371575e-01, -5.247428417e-01, 2.819763422e-01, 6.311643720e-01, 6.514374167e-02, -3.116431236e-01, 2.955246866e-01, -2.117471397e-01, -3.849393725e-01, -2.967227101e-01, 2.872507870e-01, -3.502545655e-01};
real  W113[0:33] = {6.358019114e-01, 2.115011364e-01, -4.804508090e-01, 3.915356398e-01, 2.406082153e-01, -1.640071720e-02, -1.236223131e-01, 1.692879573e-02, -2.333234251e-01, 3.471091390e-01, 9.984498024e-01, 2.765063047e-01, -4.297742993e-02, 5.527593940e-02, 6.583366990e-01, -8.959520608e-02, 4.523904920e-01, 2.432782948e-01, -4.045835435e-01, -1.636182517e-01, -6.606465578e-01, -2.359047979e-01, -2.011508793e-01, -2.035782635e-01, 6.035282016e-01, -3.825032115e-01, 2.117787451e-01, 4.299235344e-02, 4.052058160e-01, 9.878629446e-02, -6.541500986e-02, 1.121080741e-01, -3.231401742e-01, 1.013458490e+00};
real  W114[0:33] = {2.987508774e-01, -1.083904505e-01, -4.152561724e-01, 2.610938847e-01, -1.484077424e-01, 2.488802671e-01, 7.384699583e-01, 7.623311132e-02, 3.347050399e-02, -5.743110776e-01, 1.179860711e+00, -3.942521513e-01, -8.375813365e-01, 3.631041348e-01, -1.995476782e-01, -1.043484360e-01, -6.093432307e-01, -7.386085391e-01, -3.652803302e-01, 2.987450659e-01, -8.396399766e-02, 5.742589831e-01, 3.595642149e-01, -6.946617961e-01, 1.012397856e-01, -4.148162901e-01, 5.393757820e-01, -4.286331534e-01, -5.147020817e-01, -6.539580822e-01, -3.154117167e-01, 1.261358559e-01, 2.547295690e-01, 9.410030842e-01};
real  W115[0:33] = {-1.641550362e-01, -8.053962886e-02, 1.178416461e-01, 3.592091501e-01, 1.482358128e-01, -4.062221572e-02, 2.017560452e-01, -6.878435612e-01, 1.609257311e-01, 2.282233685e-01, 1.117761210e-01, 7.043965161e-03, -9.215249866e-02, -4.538136423e-01, 1.437998861e-01, 3.207252026e-01, 1.409928948e-01, 1.499049366e-01, 1.650569588e-01, 1.997554600e-01, 5.343629420e-02, -1.738693006e-02, -1.445133239e-01, 3.033988476e-01, 1.833034605e-01, -1.280783713e-01, -3.438444808e-02, 9.267622977e-02, -9.888906032e-02, -7.835829258e-02, 1.543644518e-01, -1.229394525e-01, -2.191106230e-01, 8.317064494e-02};
real  W116[0:33] = {-4.069625437e-01, 2.152787447e-01, 3.190552592e-01, -4.820601046e-01, -5.858368278e-01, -6.706064194e-02, -5.791338682e-01, 3.971128166e-01, -2.689606883e-02, -7.086753249e-01, -5.867698193e-01, -1.271820068e-01, 7.744212169e-03, -6.644734144e-01, -3.835222423e-01, -3.197912872e-01, 4.201098382e-01, -3.682212234e-01, 5.711913705e-01, -1.767003536e-01, 4.852866828e-01, 4.223482013e-01, -7.682954073e-01, -5.351318512e-03, 5.948154926e-01, 4.896002114e-01, -7.548523545e-01, 1.143165380e-01, 4.624617398e-01, 7.472717166e-01, -5.068978667e-01, -5.007781982e-01, -3.013038337e-01, 1.078480184e-01};
real  W117[0:33] = {-2.310809791e-01, 3.474361002e-01, 1.992496401e-01, -3.798843920e-01, 3.516339958e-01, 9.744153917e-02, -5.594964027e-01, -1.041761339e-01, 3.186644912e-01, -1.543727666e-01, 2.120468020e-01, 2.057514042e-01, 2.128386497e-01, -1.567926556e-01, 3.886347711e-01, -3.832707182e-02, 2.000395954e-01, 6.556546092e-01, 4.300742447e-01, 1.580108553e-01, 1.076316759e-01, -8.494938016e-01, -5.994151831e-01, 3.327647746e-01, -1.762543023e-01, 1.187950745e-01, -2.812083364e-01, 5.246468820e-03, -1.469019502e-01, 2.763531804e-01, 4.909220040e-01, 2.692708373e-01, -3.391788602e-01, 1.084275246e-01};
real  W118[0:33] = {-4.872072041e-01, -2.601146400e-01, 8.919650316e-02, -3.929211795e-01, -2.609115243e-01, 3.918866515e-01, -2.321237773e-01, -4.574449062e-01, -1.292034984e-01, -3.746121824e-01, -5.397573709e-01, -2.136339992e-01, -2.610144615e-01, 2.031484991e-01, -5.675007105e-01, -8.914399147e-02, -2.096207291e-01, -1.388601065e-01, 2.021455020e-01, 9.813641012e-02, 4.540757537e-01, -1.704378724e-01, 1.465465128e-01, 1.434601247e-01, -3.999046683e-01, 1.932034194e-01, -2.759819925e-01, -1.353534758e-01, -5.251070857e-01, -1.983844638e-01, 3.522046804e-01, -1.684787720e-01, 1.931616664e-01, -1.079177856e+00};
real  W119[0:33] = {-6.019248366e-01, -3.117034137e-01, 5.395426154e-01, -2.477741092e-01, -8.920766115e-01, 4.670280218e-01, -7.875167131e-01, 2.217900515e+00, -6.767137349e-02, -4.282089174e-01, -7.942255735e-01, -6.405211687e-01, -4.640353322e-01, -2.605279982e-01, -8.309198022e-01, -1.546714306e-01, -3.745985404e-02, -1.035995126e+00, 4.257982969e-01, 2.691538073e-02, 4.185736477e-01, 7.530058622e-01, -3.768031895e-01, 2.067504823e-01, 5.177125335e-01, -1.775829792e-01, -6.850446463e-01, -1.847554743e-01, 5.359845608e-02, 4.038071632e-01, -2.138218433e-01, -6.640990376e-01, 6.982473191e-03, -6.562804431e-02};
real  W120[0:33] = {-1.081331000e-01, 4.503640160e-02, 2.477745414e-01, 2.278138399e-01, 3.259448707e-02, -1.190108955e-01, 1.527346522e-01, -5.433958173e-01, -3.904782534e-01, -1.216068193e-01, -6.425409913e-01, -2.963722944e-01, -6.076864600e-01, -2.529658377e-02, -3.670936227e-01, 5.040849745e-02, -3.501906395e-01, -6.200436354e-01, 1.753148735e-01, 1.413437724e-01, 2.605966330e-01, 1.013820410e+00, 5.849193931e-01, -3.867178559e-01, -5.857065916e-01, 6.392676234e-01, -1.986438334e-01, 9.978634305e-03, 2.972346246e-01, 8.605176210e-02, -2.792360187e-01, -3.306310773e-01, -6.832791120e-02, -5.307144523e-01};
real  W121[0:33] = {5.936278105e-01, 1.746998876e-01, 3.259409666e-01, 8.937006593e-01, -5.531419069e-02, 4.603211284e-01, 7.044123411e-01, -9.899674654e-01, -6.048154235e-01, 9.651349187e-01, -4.102280438e-01, -1.177166849e-01, -5.301053077e-02, -2.804226875e-01, -1.118843928e-01, 5.742576346e-02, 8.813727647e-02, 2.897319794e-01, 6.236214042e-01, -3.302822635e-02, 1.785412431e-01, -3.534168005e-01, 7.735432386e-01, 7.268074155e-01, -6.044954062e-01, 1.683301628e-01, -3.257427812e-01, 1.337295771e-01, 3.633957207e-01, -3.747120202e-01, -1.919334233e-01, 1.867831647e-01, -7.597786784e-01, 2.087103128e-01};
real  W122[0:33] = {2.470525652e-01, -4.567941427e-01, 1.596990079e-01, 2.922765911e-01, 2.893676981e-02, 3.277820051e-01, 3.687136769e-01, -1.277608633e+00, -1.041188464e-01, 5.411005616e-01, 5.682293177e-01, 9.019236267e-02, -3.737384379e-01, -5.141786337e-01, -1.060462371e-01, 5.601635575e-01, 6.853461266e-02, -3.677397668e-01, 4.210831821e-01, 2.570208907e-01, 1.350104660e-01, -3.276114762e-01, -3.831538856e-01, 2.624689937e-01, -6.532853097e-02, -9.766292572e-01, -1.863155216e-01, -1.410580426e-01, -2.026291937e-02, -7.604945302e-01, 2.647010684e-01, 2.819201350e-01, -7.944095135e-01, 2.193048745e-01};
real  W123[0:33] = {2.237076759e-01, -7.833910733e-02, 3.946820796e-01, 4.010459483e-01, -9.311614931e-02, 9.692046791e-02, 2.788512111e-01, -1.737795472e+00, -5.583940148e-01, 2.919529676e-01, -5.548359752e-01, -2.365993708e-02, -4.592092931e-01, -4.465157092e-01, 1.081059650e-01, 3.496326804e-01, 2.203706801e-01, -3.335274383e-02, 2.777059972e-01, -3.655663133e-01, -6.107039750e-02, -9.792472422e-02, 1.936549395e-01, 3.881329000e-01, -4.226081371e-01, 1.990019083e-01, 8.441892266e-02, -1.602082849e-01, 1.092104241e-01, 9.343472123e-02, 1.556912363e-01, 1.627829522e-01, -6.066831350e-01, -1.872722208e-01};
real  W124[0:33] = {-1.694518477e-01, -4.803732336e-01, 2.901577652e-01, -5.771800131e-02, 4.096109048e-02, 3.654933572e-01, -3.608735502e-01, -2.207936496e-01, 3.114386499e-01, 4.071343690e-02, 6.209492683e-01, -2.806892097e-01, -2.849824429e-01, -4.794404283e-02, -8.802195638e-02, 3.272008002e-01, -1.507915854e-01, -1.372819245e-01, 6.859513521e-01, 5.333738923e-01, -1.875035167e-01, -6.533665955e-02, -2.797339559e-01, 3.654168844e-01, 1.061403193e-02, -1.304710984e+00, -2.748186290e-01, 5.237407610e-02, -6.513025165e-01, -1.228020042e-01, -1.210919246e-01, -1.902839839e-01, 2.536042966e-02, 3.371610641e-01};
real  W125[0:33] = {1.905238070e-02, 3.997299373e-01, -2.004312724e-01, 2.319288999e-01, 3.742021024e-01, -3.134389818e-01, -1.023102850e-01, 3.056032583e-02, -8.974362165e-02, -3.540637195e-01, -1.541231990e+00, 4.588519037e-02, 5.675311014e-02, 1.224649772e-01, 1.226562485e-01, -3.574926555e-01, -4.049966931e-01, 1.097168326e-01, -3.483198285e-01, -9.077687263e-01, -1.484569907e-01, -2.925902903e-01, 2.819528580e-01, 8.619916439e-02, 8.855552971e-02, 3.329927683e+00, 4.847931266e-01, 1.262610555e-01, 2.594285011e-01, 5.853090808e-02, -4.176037312e-01, 1.085188612e-01, -2.035479248e-01, -1.466461569e-01};
real  W126[0:33] = {-1.827124506e-01, -3.257349506e-02, -3.498376906e-01, -3.905940354e-01, 1.845302731e-01, -1.359558254e-01, -3.022412211e-02, 8.812106848e-01, -4.160728455e-01, -7.056258917e-01, -3.713125885e-01, 1.710420474e-02, -1.075002179e-01, 5.044981241e-01, -3.468159214e-02, -5.038520098e-01, -3.025157154e-01, -5.793350190e-02, -4.262617528e-01, -1.701521128e-01, -3.804444969e-01, 3.705282211e-01, 1.661152840e-01, -6.524966359e-01, 1.034794375e-01, 6.655051112e-01, 1.955220699e-01, -2.108441293e-01, 3.541316986e-01, 1.702136844e-01, -3.583101630e-01, -3.242430985e-01, 5.429670811e-01, 2.107855231e-01};
real  W127[0:33] = {-4.917307794e-01, -2.031347305e-01, -7.088831067e-01, -8.942489624e-01, 1.115609631e-01, -1.433251426e-02, -9.787052870e-01, 1.251910448e+00, 8.922223449e-01, -4.709268510e-01, 1.587802887e+00, 1.039751321e-01, 9.521806240e-01, 4.538044035e-01, -1.939175278e-01, -8.733290434e-01, -2.201516181e-01, 1.040492058e+00, -5.467851758e-01, 3.254320920e-01, 5.819584802e-02, -1.052753687e+00, -8.937005997e-01, 1.973299533e-01, 2.554048225e-02, -6.370330453e-01, 6.667359471e-01, -2.157173306e-01, -3.777755499e-01, -2.291826308e-01, 1.264606863e-01, -2.667373121e-01, 8.617289662e-01, 6.402856708e-01};
real  W128[0:33] = {-1.013233781e+00, -6.904397607e-01, 5.537269711e-01, -7.373602986e-01, -4.954991937e-01, -4.725746438e-02, -5.869674087e-01, 9.965122938e-01, 4.989746213e-02, -7.983346581e-01, -4.692141712e-01, -1.217861548e-01, -4.461668432e-01, 9.568700194e-02, -3.309361339e-01, -1.873977333e-01, -1.249024391e+00, -4.243057668e-01, 3.530137986e-02, 2.949753404e-01, 3.132783175e-01, 4.563234150e-01, 3.836435676e-01, -3.464955986e-01, 7.266571373e-02, 2.200947553e-01, -3.032223284e-01, -4.001683593e-01, -4.894224405e-01, 1.140168682e-01, -1.514553130e-01, -4.077240825e-01, 5.979409218e-01, 1.106664911e-01};
real  W129[0:33] = {4.239121377e-01, 4.174393415e-02, -1.782357693e-01, 4.522807300e-01, 3.100172803e-02, 5.429309607e-02, 1.480085496e-02, -1.053195596e-01, -1.308570951e-01, -3.918807507e-01, -8.655510545e-01, -1.674207896e-01, -5.033159852e-01, 4.375602007e-01, -3.100509942e-01, -9.702584893e-02, -5.286943540e-02, -1.663020402e-01, -2.235261910e-02, -5.107474923e-01, -1.598445922e-01, 1.766199768e-01, 8.870691657e-01, -1.984637827e-01, -6.425277144e-02, 1.123454690e+00, 2.928418666e-02, 1.331623346e-01, 1.084531099e-02, 1.741310954e-01, -2.449504882e-01, 2.401685268e-01, -2.619586326e-02, -5.950965360e-02};
real  W130[0:33] = {-4.919168949e-01, 2.055834047e-02, -1.176478267e-01, -1.671936922e-02, -2.699796259e-01, 2.457500845e-01, 1.407123953e-01, -3.198295534e-01, 1.486680508e-01, -1.053476408e-01, -4.952343702e-01, -1.076293876e-03, 1.167155057e-01, -2.470972687e-01, -3.764725924e-01, 1.539782733e-01, 1.854031906e-02, -2.145878077e-01, -2.622471452e-01, -4.014048353e-02, 1.514597237e-02, -4.064385295e-01, 2.013710588e-01, 2.696347423e-03, -7.742080837e-02, 5.136327744e-01, -4.366398156e-01, 7.829281688e-02, -3.279007971e-01, -1.438616067e-01, 2.054941356e-01, 3.593793511e-02, 4.070977867e-01, -8.071404696e-01};
real  W131[0:33] = {7.593657374e-01, 4.671293199e-01, -1.286724210e-01, 6.454452872e-01, 3.714201748e-01, -3.283873498e-01, 5.227021575e-01, -6.391734481e-01, 1.306653768e-01, 2.652900219e-01, 4.631302357e-01, 5.440382361e-01, 6.029513478e-01, -1.654061824e-01, 3.226596862e-02, 2.014378011e-01, 8.897961378e-01, 3.206756338e-02, 4.376555607e-02, -5.316334367e-01, -5.249232054e-01, -2.556635737e-01, -4.289778471e-01, 8.134137094e-02, -1.437666863e-01, -2.067445070e-01, 6.338936687e-01, 4.437514246e-01, 2.482233793e-01, 2.185934484e-01, -2.295948267e-01, 2.823053300e-01, -2.332244217e-01, 2.593668401e-01};
real  W132[0:33] = {1.619703323e-01, 2.231766880e-01, -2.573181689e-01, -2.471788675e-01, 1.387175620e-01, -1.485866904e-01, 2.317215800e-01, 1.850642264e-01, 4.553180635e-01, 1.966381632e-02, 2.636121035e+00, 1.029340252e-01, 4.116328955e-01, 2.597543001e-01, 4.632298946e-01, -5.385204032e-02, 1.759650111e-01, 5.207261443e-02, 1.397063732e-01, 4.042365253e-01, -1.520968229e-01, -6.456470490e-02, 1.237467900e-01, 3.208319843e-02, -1.067641079e-01, -1.830127835e+00, -2.595712431e-05, 2.344810814e-01, 4.100386202e-01, -1.647754014e-01, -2.239965051e-01, 1.283933818e-01, 1.862693019e-02, 4.576032460e-01};
real  W133[0:33] = {-2.281354368e-01, -3.999792337e-01, 2.000613511e-01, 5.987200886e-02, -2.594354004e-02, 2.010415047e-01, 6.464150548e-02, -1.308981627e-01, 9.060488641e-02, -2.635217905e-01, -4.901266396e-01, -1.274214089e-01, 4.155132174e-02, -1.474340558e-01, -2.541248500e-01, 2.317772359e-01, -1.746198833e-01, -9.924903512e-02, 1.935553178e-02, 7.374422997e-02, -3.175809979e-02, 1.248900592e-01, 1.935288608e-01, 2.005899996e-01, -9.984243661e-02, 5.966721177e-01, 1.397443861e-01, -1.785952300e-01, -2.041057050e-01, -7.258136570e-02, 5.297586694e-02, -2.767737508e-01, 4.256098531e-03, -6.761120558e-01};

real  B1[0:33] = {-5.149754882e-01, -3.678864241e-01, 2.145197093e-01, -1.572119892e-01, -2.921145856e-01, 2.506511509e-01, 4.494877905e-02, -2.325542867e-01, 1.789276302e-01, 5.311815767e-04, -1.068387628e-01, -4.283581972e-01, -3.238516450e-01, -1.963292062e-01, -2.075437903e-01, 2.826757431e-01, -2.707825899e-01, -1.776101142e-01, 3.436596990e-01, 2.673089802e-01, 3.205944002e-01, -3.665705398e-02, 1.862731129e-01, 2.732465863e-01, -1.736799181e-01, -1.340758651e-01, -5.016357899e-01, -2.307359576e-01, -3.906882405e-01, -2.060221732e-01, 4.005572498e-01, -2.430408895e-01, -8.843081445e-02, -2.914737463e-01};
// --- HiddenLayer3 ---
real  W20[0:33] = {1.680589169e-01, -1.092770457e+00, -2.018755674e+00, -2.243727446e-01, 1.032872438e+00, -1.059607029e+00, 4.269144535e-01, 4.534722567e-01, -9.747155011e-02, -9.249798208e-02, -7.826232314e-01, 2.130343616e-01, -1.687282681e+00, -3.571626544e-01, -2.987842560e-01, -1.100569129e+00, -1.297253370e+00, 6.969599724e-01, 9.781931639e-01, -7.210443616e-01, 6.700413674e-02, 1.551242948e+00, -1.157462835e+00, -9.813707471e-01, 3.124076426e-01, -6.717811823e-01, 1.823483109e+00, -4.427061975e-01, -2.166119069e-01, 1.607844114e+00, 9.818448126e-02, -5.513224602e-01, 4.454300106e-01, 8.170457482e-01};
real  W21[0:33] = {-4.304527342e-01, 2.874805629e-01, 6.086626672e-04, -9.545907378e-01, -3.719843030e-01, 4.774085581e-01, -1.072316766e-01, 2.054570764e-01, 2.494176626e-01, -4.005664960e-02, 4.429524839e-01, 3.975521028e-01, -1.701343507e-01, 1.647128724e-02, 3.468854120e-03, 5.757068992e-01, 3.342254162e-01, -8.248572350e-01, -5.938762426e-01, -3.930922151e-01, 6.186980754e-03, -4.625432789e-01, -4.200901091e-01, 7.912374102e-03, 6.280325055e-01, 4.509715438e-01, -1.730976105e-01, -4.697708786e-02, -8.317537904e-01, -1.109751537e-01, -1.628449857e-01, -7.209378481e-01, 4.676689506e-01, 2.636826932e-01};
real  W22[0:33] = {8.186640143e-01, 4.429263249e-02, -8.074964285e-01, 3.019799292e-01, 3.803508580e-01, -2.593981922e-01, 7.326153517e-01, 2.566701770e-01, -4.093187153e-01, -4.133213460e-01, -5.618327856e-01, -7.417196780e-02, 1.878684610e-01, -7.054621577e-01, 3.472662270e-01, -6.806102395e-01, -3.140226305e-01, 4.580103159e-01, 8.022518158e-01, 3.862974048e-01, -7.072923332e-02, 9.039510787e-02, 3.688616455e-01, -1.658742875e-01, 9.815665893e-03, -3.370499909e-01, 1.608165950e-01, 3.543360531e-01, 5.561805367e-01, 1.443708688e-01, 4.907020926e-01, 5.355876088e-01, -2.754704952e-01, 1.359095275e-01};
real  W23[0:33] = {5.154139996e-01, 2.225082517e-01, -6.387884617e-01, -4.949647188e-01, -2.551200092e-01, -4.950530827e-01, -2.176219374e-01, -3.354136646e-01, 4.059782028e-01, 1.724018604e-01, -6.491251588e-01, 1.886404455e-01, -2.084249705e-01, 7.551645041e-01, -1.384809136e+00, -6.314971447e-01, -6.935957670e-01, 7.852697968e-01, 2.909104526e-01, -8.244597316e-01, 8.604375124e-01, 5.302222371e-01, -6.167880297e-01, -6.256310344e-01, 1.430178732e-01, -2.235148847e-01, 1.004961491e+00, -1.893445253e-01, -4.839793742e-01, 5.998765305e-02, 3.481249809e-01, -7.580024600e-01, 1.680554003e-01, 9.069002271e-01};
real  W24[0:33] = {-2.369348891e-02, 7.051609755e-01, 1.542194635e-01, -1.270825714e-01, -1.872774810e-01, 3.098162413e-01, -7.058896422e-01, -8.407793641e-01, 2.342093587e-01, -7.825120538e-02, 2.508703433e-02, 6.153940558e-01, 2.412189096e-01, 3.936428130e-01, 1.058003902e-01, -1.518376321e-01, -3.362255991e-01, -2.181295305e-01, 9.625103325e-02, -4.874512255e-01, 2.497859672e-02, 1.118100733e-01, -9.867352843e-01, 7.048534155e-01, -5.697199106e-01, 4.271056950e-01, -9.677550942e-02, -9.344590902e-01, -4.113171697e-01, -5.889100432e-01, 3.038592823e-02, -2.463320345e-01, 4.187252522e-01, 3.208350241e-01};
real  W25[0:33] = {-1.769297384e-02, -4.836142361e-01, -9.943158627e-01, 7.523533106e-01, 2.437561601e-01, 8.504841477e-03, 3.627704382e-01, 5.502509326e-02, 1.441684458e-02, 1.879804432e-01, -4.467423856e-01, -1.124367490e-01, -3.231893480e-01, -3.605041802e-01, 2.485499531e-01, -6.828072667e-01, -9.826868176e-01, 5.114032626e-01, 5.852189660e-01, 5.492287874e-01, -5.070770159e-02, 4.240560532e-01, -4.756667316e-01, 3.018472195e-01, 1.863034517e-01, -3.950886726e-01, 1.015766859e+00, 2.561725676e-01, 5.499163866e-01, 2.972951829e-01, 2.907976806e-01, 4.261169136e-01, -3.695126474e-01, -3.125829399e-01};
real  W26[0:33] = {4.125945270e-01, 9.402554482e-02, 2.434099466e-01, -1.160083055e+00, -8.864752054e-01, -2.371585667e-01, -5.009363294e-01, -7.539619803e-01, 4.341658354e-01, 3.536826074e-01, -7.388560176e-01, -2.766103745e-01, -3.629281521e-01, 6.783714294e-01, -7.055832744e-01, -6.068093777e-01, 1.066887528e-01, 6.511336565e-01, 1.127728581e+00, -1.356415749e-01, 1.013464093e+00, 1.298191547e-01, 2.345155180e-01, 1.938783675e-01, 5.093512312e-02, -1.180880904e+00, 2.041881680e-01, -1.813693941e-01, -1.005716443e+00, -2.131634355e-01, 8.964996338e-01, -3.372733295e-01, 3.682337999e-01, 3.562226295e-01};
real  W27[0:33] = {4.005008563e-02, -2.688270509e-01, -1.397515982e-01, 2.236128896e-01, 8.880916238e-01, -1.170217432e-02, 1.644870788e-01, 3.092575967e-01, 7.822557092e-01, 1.315311044e-01, 1.617318541e-01, 5.958073735e-01, -1.203732252e+00, -9.485539794e-01, 5.615369678e-01, 9.997428395e-03, -3.525353670e-01, 6.153231114e-02, -1.912838221e-01, -6.512508392e-01, -5.556413531e-01, -1.598337442e-01, -8.178865314e-01, 1.220253631e-01, -7.297267020e-02, -3.742174804e-02, -3.198871911e-01, -5.013984442e-01, -5.817382336e-01, 5.838211626e-02, -4.286868870e-02, 1.587536484e-01, -5.613567308e-02, 1.175291657e+00};
real  W28[0:33] = {1.521155834e-01, -1.427350044e-01, 7.574875951e-01, -8.153911829e-01, -7.520334721e-01, 1.349169463e-01, -6.353673339e-01, -9.670481831e-02, 9.377866238e-02, 1.156312749e-01, 2.488826960e-01, -1.948939264e-01, 7.145604491e-01, 6.677762866e-01, -1.103706717e+00, -2.911186814e-01, -3.666850626e-01, 5.952324867e-01, 2.745196521e-01, -2.064149082e-01, 3.420252204e-01, -7.408908606e-01, -5.498973131e-01, -4.959093034e-01, 4.655962288e-01, -1.930084825e-01, -1.175723150e-01, -4.490802884e-01, -9.740427136e-02, 7.789329439e-02, 8.252233267e-01, -4.752638936e-01, 9.538977593e-02, 4.600332975e-01};
real  W29[0:33] = {3.202445805e-01, -4.190365672e-01, 3.805204034e-01, -4.312958419e-01, 2.856816351e-01, -9.600278139e-01, -4.525257945e-01, 3.563416749e-02, 1.011544093e-01, -2.466354072e-01, -4.455288053e-01, 5.642916560e-01, 4.174410105e-01, 3.637925982e-01, -5.933193862e-02, -5.897351503e-01, -2.488785684e-01, 8.239125609e-01, 3.471608162e-01, -2.214651406e-01, 1.748210639e-01, -1.324039549e-01, 1.208335683e-01, -2.762790024e-01, 4.897446036e-01, -7.194973230e-01, 5.511355996e-01, -7.441032529e-01, -5.309481025e-01, 3.156307638e-01, 3.598527014e-01, -4.902834892e-01, 6.438630223e-01, 3.687461913e-01};
real  W210[0:33] = {-4.562102854e-01, -2.185259014e-02, 6.562342644e-01, -5.148023963e-01, -3.246874809e-01, -2.212205976e-01, -1.124128699e+00, -8.199990541e-02, 8.636517525e-01, -1.279120326e+00, 9.710965753e-01, 5.660666823e-01, -8.046690822e-01, 1.107784152e+00, -1.060588479e+00, 9.074522853e-01, 4.443399608e-01, -2.349610478e-01, -2.098316997e-01, -4.768621624e-01, -1.036730409e+00, -8.038559556e-01, -5.416004062e-01, -1.249421462e-01, -1.042757183e-02, 4.662184417e-01, -6.849366426e-01, -6.321394444e-01, -3.612803221e-01, 1.967114210e-01, 3.864311576e-01, -7.590357661e-01, 7.131035328e-01, 3.380909562e-01};
real  W211[0:33] = {-5.189746618e-01, 5.481489897e-01, 3.832626641e-01, -4.030978978e-01, -3.308998346e-01, 5.231766105e-01, -5.480997562e-01, -2.708151340e-01, 2.489950806e-01, 2.222223766e-02, 1.711513698e-01, 4.412060231e-02, 2.460115552e-01, 1.557664424e-01, -4.647033811e-01, -8.490809053e-02, 4.304957688e-01, -2.345681787e-01, -3.723665476e-01, 1.437070370e-01, 4.169704616e-01, -3.921116292e-01, 2.286623716e-01, 4.200200140e-01, -3.051069975e-01, 4.062029421e-01, -1.544198096e-01, -1.084500626e-01, -1.236460507e-01, -1.062394828e-01, -1.600013077e-01, -8.267632127e-02, 9.771312587e-03, 9.291538596e-02};
real  W212[0:33] = {6.438787580e-01, -1.526488423e+00, -1.348258376e+00, 1.224611402e+00, -9.216022491e-01, -1.542357445e+00, -2.407854944e-01, 6.446460485e-01, 3.252520561e-01, -1.163158789e-01, -9.772243500e-01, 6.767051220e-01, -1.728417516e+00, 8.446310163e-01, -1.002692342e+00, -1.351878166e+00, -9.901648164e-01, 1.025346637e+00, 1.322952628e+00, 3.907108605e-01, 7.124955058e-01, 1.920007110e+00, -4.728508592e-01, -1.166491151e+00, 6.880798936e-01, -9.870169759e-01, 2.089588404e+00, 1.637060754e-02, 6.997857094e-01, 1.709176064e+00, 3.847206533e-01, -2.125451118e-01, 6.318832748e-03, 2.144552916e-01};
real  W213[0:33] = {-6.159792095e-02, 2.958104312e-01, 2.425679117e-01, -3.627268374e-01, -4.591397047e-01, -3.936879039e-01, -7.317489386e-01, 2.124187797e-01, 3.474938571e-01, -2.491430044e-01, -2.533011138e-01, 9.520930797e-02, 3.580123782e-01, 5.730107427e-02, 7.145604491e-02, -1.043905616e-01, 7.324571013e-01, -2.092691660e-01, -1.652160436e-01, -9.133600444e-02, 4.888413846e-02, 1.450395584e-01, -5.547090173e-01, 2.249314040e-01, 3.529860824e-02, 2.875491083e-01, 2.027670294e-01, -5.743435621e-01, -1.486018449e-01, 1.300398409e-01, -2.098350376e-01, -1.995315701e-01, 2.310385108e-01, 4.422921315e-02};
real  W214[0:33] = {-2.755388021e-01, -2.009789199e-01, 1.379061192e-01, -1.807070971e-01, -1.420074105e-01, -2.165529728e-01, -1.625989079e-01, -5.818470716e-01, 7.990381718e-01, -1.540256590e-01, -1.583665460e-01, 4.788146615e-01, -5.072811246e-01, 8.784449100e-01, -4.977897704e-01, 2.069217414e-01, 4.006921351e-01, -1.563171297e-01, -3.624464273e-01, 1.107609347e-01, 3.680725931e-04, 2.813212276e-01, -6.025521457e-02, 1.272352040e-01, -3.803918660e-01, 1.256558448e-01, 9.344085306e-02, -2.977893949e-01, -6.318453550e-01, -2.175638676e-01, -4.067769647e-01, -7.087641954e-01, 8.434827328e-01, 2.369486541e-01};
real  W215[0:33] = {2.915060520e-01, -4.150761962e-01, -2.939849719e-02, -1.734840684e-02, -8.475653827e-02, -4.292966425e-01, -6.173030138e-01, 2.187772542e-01, 3.733239770e-01, -1.280427426e-01, -6.467660517e-02, 2.088466585e-01, 2.165640593e-01, 4.764502943e-01, 1.315915287e-01, -1.122858375e-01, -1.538564265e-01, 4.290335178e-01, -1.543996781e-01, -1.699586064e-01, -6.215108037e-01, 3.675823808e-01, 2.662548795e-02, -4.475904405e-01, 5.805250406e-01, -5.400971174e-01, 8.380158246e-02, 2.756280899e-01, 7.966523618e-02, 3.274947107e-01, 2.888385057e-01, -3.189221323e-01, -1.168205813e-01, -1.088206023e-01};
real  W216[0:33] = {-6.860491633e-01, 5.243253112e-01, -1.915884018e-01, -1.527271979e-02, -9.887682647e-02, 2.541038990e-01, -2.554056346e-01, -5.313702822e-01, -2.785706222e-01, 1.802279353e-01, 6.864127517e-01, 1.183393821e-01, -3.616904020e-01, -5.540478230e-01, 3.653710186e-01, 1.444132626e-01, 3.188109398e-01, 1.430325210e-01, 5.816593021e-02, -3.297537863e-01, -1.467675269e-01, -1.200999096e-01, -7.035340071e-01, 8.091714382e-01, -5.631394982e-01, 2.633181512e-01, -3.208563030e-01, -2.098097652e-01, -9.414962530e-01, -9.358681440e-01, -1.718577892e-01, -4.234553874e-02, 6.724973917e-01, 3.434870243e-01};
real  W217[0:33] = {2.119897399e-03, 4.357237518e-01, -6.155384704e-02, -2.935998142e-01, -2.843634784e-01, 7.370290160e-01, -2.799207270e-01, -5.644502640e-01, 9.177045226e-01, 2.288071997e-02, -2.462908328e-01, 2.933183312e-01, 2.241467983e-01, 1.165619254e+00, -1.380935550e+00, -9.494315982e-01, -7.281986624e-02, 5.853043795e-01, 8.192531765e-02, -7.191407681e-01, 1.074779510e+00, 3.386417031e-01, -9.745354205e-02, 2.669620812e-01, -8.078696728e-01, 9.815262258e-02, 1.102309465e+00, -7.669988871e-01, -2.315939218e-01, 2.848443687e-01, 4.174144566e-01, -7.687811852e-01, 2.586445510e-01, 3.391131163e-01};
real  W218[0:33] = {8.111110330e-01, 4.422397166e-02, -5.622143149e-01, 3.680519760e-01, 3.628067970e-01, -1.453387439e-01, 2.929463089e-01, -9.919594228e-02, -2.220670283e-01, 4.676953703e-02, -6.612027287e-01, -1.145596616e-02, -5.850395560e-01, 5.786825716e-02, -3.003148139e-01, -5.739693530e-03, -8.919302225e-01, 1.833461076e-01, 4.523640871e-01, -1.885015815e-01, 1.361598521e-01, -5.188272521e-02, 1.507550836e+00, 1.131878570e-01, 4.250446856e-01, -1.209106222e-01, -1.828937680e-01, 1.699559987e-01, 2.589614391e-01, -2.882728577e-01, -1.925084442e-01, -4.316186011e-01, -2.202845067e-01, -1.742681675e-02};
real  W219[0:33] = {-2.103244215e-01, -2.256150693e-01, -8.326165080e-01, 3.714585006e-01, 6.634025574e-01, 2.873709798e-01, -1.736712456e-01, 3.441300988e-01, 2.103137597e-02, 8.289901167e-02, -3.064741492e-01, -2.123040706e-02, 1.339543462e-01, -9.763784409e-01, 7.833908200e-01, -8.546616435e-01, -6.381570101e-01, 6.934889555e-01, 3.908391893e-01, -1.172569208e-02, 5.652256012e-01, 3.170503676e-01, 4.273667037e-01, 7.629623264e-02, 5.873664096e-02, -4.222083390e-01, 7.424464822e-01, 8.215826005e-02, 3.150867224e-01, 4.361277819e-01, 2.925099134e-01, 8.005855083e-01, -6.993295550e-01, -6.433961987e-01};
real  W220[0:33] = {-5.381453782e-02, -3.178009093e-01, -7.639806271e-01, 1.208670497e+00, 7.847211957e-01, -5.159871578e-01, 2.625687420e-01, 2.186708748e-01, -4.842867851e-01, -1.488575339e-01, -2.167665958e-01, 3.051823676e-01, 6.280406713e-01, -5.063314438e-01, 1.122747064e+00, -4.558270574e-01, -4.448308051e-01, 2.234102041e-01, 3.447580338e-01, 3.776594400e-01, 1.826826334e-01, 4.508414268e-01, 6.191078201e-02, -3.519031405e-01, 4.596573412e-01, -2.712672353e-01, 3.857931197e-01, 6.363800764e-01, 4.691577554e-01, 5.454711318e-01, 7.565528154e-01, 8.149509877e-02, -5.457704663e-01, -7.351114154e-01};
real  W221[0:33] = {-5.740327239e-01, -1.857162863e-01, 7.083588243e-01, 5.450892448e-01, 3.547525704e-01, -2.391834110e-01, 6.545870304e-01, 8.447321653e-01, -6.514570117e-01, -3.689057827e-01, 5.072135925e-01, -4.730954170e-01, 3.868873119e-01, -1.301508307e+00, 1.249006033e+00, 5.325590372e-01, 3.390708938e-02, -6.441252828e-01, -5.753778219e-01, 4.137688875e-01, -6.120095253e-01, -3.770991266e-01, -3.890517950e-01, -3.488596380e-01, 1.248888765e-02, 2.931884527e-01, -1.143639922e+00, 4.565790594e-01, 4.944645166e-01, 2.706813216e-01, -8.542152494e-02, 8.204726577e-01, -2.921453416e-01, -1.618046314e-01};
real  W222[0:33] = {-1.067969725e-01, -2.060431093e-01, 7.637009621e-01, -3.756457269e-01, 6.550472379e-01, 7.439974546e-01, 1.391605139e+00, 1.359773427e-01, -6.467405558e-01, -7.239404917e-01, 4.896016121e-01, -3.117298484e-01, -3.297248483e-01, -9.683907628e-01, 4.671678543e-01, 5.386928916e-01, 9.170302749e-01, -6.316701770e-01, 1.805515587e-02, 4.313558936e-01, -6.473877281e-02, -1.664547324e-01, 1.486202329e-01, 6.937937140e-01, -1.227512836e+00, 6.046838760e-01, -4.994678497e-01, 7.021238208e-01, 5.104017258e-01, -4.453184307e-01, -6.512987018e-01, 2.905556262e-01, -9.842895269e-01, -1.035560131e+00};
real  W223[0:33] = {4.924468994e-01, 1.449245065e-01, -1.756655872e-01, -5.529820323e-01, -1.592715830e-01, -1.620853879e-02, 4.528319091e-02, 6.667912006e-02, -2.147217989e-01, -1.054525928e-04, -5.080804229e-01, -4.615158439e-01, -8.346555233e-01, 1.787975132e-01, -5.542867184e-01, -8.720988780e-02, -9.797683358e-02, -9.285315126e-02, 1.344068646e-01, -1.328236461e-01, -3.294835389e-01, -1.777670234e-01, 9.102163315e-01, -1.129843071e-01, 4.362268448e-01, -3.638288081e-01, 5.891356990e-02, 4.364791885e-02, -1.898242235e-01, 4.187004864e-01, 6.541568637e-01, -1.604880840e-01, 2.504070057e-03, 1.784735471e-01};
real  W224[0:33] = {-2.512395680e-01, 3.455646336e-01, -2.622177601e-01, -7.150994986e-02, 4.144333303e-02, 2.600527108e-01, 1.028813839e+00, -9.132648259e-02, -2.893096209e-01, -1.099189594e-01, -1.573529691e-01, -1.861058474e-01, 1.052417830e-01, -1.747865975e-01, 7.765163779e-01, 2.704938054e-01, -2.276808023e-01, -5.044697225e-02, 5.279494524e-01, -5.160351396e-01, -7.291121036e-02, -2.067734301e-01, 3.933715224e-01, 3.851344883e-01, 2.290441543e-01, 7.176510096e-01, -5.227285624e-01, -1.513238251e-02, -4.892711937e-01, -7.640619874e-01, -9.661905766e-01, 2.307821363e-01, 3.748163879e-01, 2.667836845e-01};
real  W225[0:33] = {5.781196430e-02, 2.539376915e-01, 6.246417165e-01, -3.275340199e-01, -8.645616770e-01, -5.070421696e-01, -6.299700141e-01, -4.210185111e-01, 7.634384036e-01, -1.364576697e+00, 9.797260165e-01, 1.001030859e-02, -9.893357754e-01, 1.458693504e+00, -1.117611527e+00, 9.268293977e-01, 3.535216749e-01, -2.882846296e-01, -9.585882723e-02, -4.968053997e-01, -8.383780122e-01, 1.543816645e-02, -2.242471129e-01, -2.707379460e-01, -2.762878835e-01, 3.073606789e-01, -9.015392661e-01, -5.815235972e-01, -2.798624039e-01, -8.625344634e-01, -5.673335195e-01, -7.320467830e-01, 6.615161896e-01, 7.243215442e-01};
real  W226[0:33] = {-8.077470064e-01, -5.056777596e-01, 7.230889201e-01, -9.277933836e-01, -5.667593479e-01, 4.500745237e-01, -7.445873022e-01, -4.531988800e-01, 5.254785419e-01, 9.093548656e-01, 6.115325093e-01, 4.010465443e-01, 4.331101775e-01, 5.800882578e-01, -3.110442162e-01, 2.961671352e-01, 4.739730358e-01, -6.771795154e-01, -1.145569444e+00, -1.548344791e-01, 6.185117960e-01, -3.579464257e-01, -2.497731894e-01, -4.188741744e-01, 3.984172344e-01, 2.510129809e-01, -5.179566145e-01, -1.102442622e+00, -6.595947146e-01, 4.104186296e-01, 3.098627627e-01, -2.016513199e-01, 1.039154053e+00, 1.966645271e-01};
real  W227[0:33] = {7.684165984e-02, 4.747904539e-01, 9.555728734e-02, -2.526426911e-01, -2.840106487e-01, 2.365340590e-01, -4.812969267e-02, -2.617741823e-01, 8.266059449e-04, 1.723711342e-01, -5.291291513e-03, 7.421384752e-02, 1.306365877e-01, 1.357118338e-01, -2.818776369e-01, 2.779099941e-01, 5.032187104e-01, -3.257687390e-01, -1.400284320e-01, -3.352915868e-02, -3.103532493e-01, -5.556722879e-01, -1.341110021e-01, 1.068639904e-01, -5.491975546e-01, 2.348927706e-01, -1.072080880e-01, 2.217004597e-01, -9.517090768e-02, -6.084262133e-01, -2.610244453e-01, -4.546568692e-01, 4.308741093e-01, 4.734823406e-01};
real  W228[0:33] = {-3.999622762e-01, 1.377533227e-01, -5.947937816e-02, -8.560976982e-01, -1.718293726e-01, 5.218498111e-01, 1.475658417e-01, -5.894472003e-01, 2.105243970e-03, 2.208068222e-01, 2.266709805e-01, 1.160059646e-01, 3.632012904e-01, -3.162190616e-01, -3.181836307e-01, 3.317162097e-01, 2.538662255e-01, -1.822597384e-01, -8.459894657e-01, -6.658381224e-01, 1.900464743e-01, -6.638230383e-02, -5.449422002e-01, 5.100317597e-01, -4.916243255e-01, 6.951186657e-01, -6.508727670e-01, -3.559975922e-01, -4.079044759e-01, -6.574298739e-01, -1.174326777e+00, -4.425780177e-01, 3.556673825e-01, 4.526993036e-01};
real  W229[0:33] = {-4.371399805e-02, 3.027307801e-02, -3.526543677e-01, 4.603165388e-01, 1.271170974e-01, -1.567933559e-01, 1.246811867e+00, -8.744506240e-01, -2.195288539e-01, -6.182384491e-01, -7.185943723e-01, -1.233827844e-01, -7.721421123e-01, -6.542602777e-01, 1.278056055e-01, -7.096692324e-01, -8.187714219e-01, 3.333252072e-01, -1.934602857e-01, 1.830294579e-01, 1.698143184e-01, 4.655177891e-01, 1.082010418e-01, -9.365725517e-02, -8.258567452e-01, -8.051884919e-02, 4.843305051e-01, 2.649678290e-01, -1.365268826e-01, -2.233978957e-01, -4.594660401e-01, -1.766725183e-01, -1.614927202e-01, 7.390040904e-02};
real  W230[0:33] = {-2.534695864e-01, -5.682085752e-01, -9.463272989e-02, -8.318094909e-02, 3.580242097e-01, -1.507524103e-01, 1.212905496e-01, 2.426737100e-01, -2.427931279e-01, -1.440182775e-01, 7.618751377e-02, -2.938089669e-01, 4.066713527e-02, -1.440114528e-01, 2.084767222e-01, -8.947384357e-01, -9.880881011e-02, 9.524170160e-01, 5.824027210e-02, 4.155105352e-01, 2.829349227e-02, 2.883649990e-02, 2.032664269e-01, -1.377890706e-01, 6.984078288e-01, -7.445979118e-01, -2.102926373e-01, 3.466658592e-01, -3.530725837e-01, 9.361218214e-01, 1.840670854e-01, 2.908920683e-02, -3.012104034e-01, -3.313668966e-01};
real  W231[0:33] = {-1.933282465e-01, 4.733510613e-01, -1.890970916e-01, -3.410599530e-01, -9.131668210e-01, 3.786676377e-02, -3.567523956e-01, -9.283261299e-01, 4.714300632e-01, 3.021926582e-01, -4.313997626e-01, 1.154423207e-01, -1.543835242e-04, 6.931676865e-01, -1.249999046e+00, -7.543449402e-01, -1.856640875e-01, 5.872802138e-01, 3.824219406e-01, -5.383371115e-01, 4.165012538e-01, 6.878063828e-02, -6.282153726e-02, 1.597947329e-01, -2.216783911e-01, 9.510775656e-02, 3.208388686e-01, -5.001951456e-01, -2.747855783e-01, 1.170430630e-01, 2.410704792e-01, -4.770674109e-01, 4.636604488e-01, 4.257602394e-01};
real  W232[0:33] = {-6.554493308e-01, -1.437148750e-01, 6.485696435e-01, -8.607955575e-01, -9.320966899e-02, 7.774706930e-02, -3.583527803e-01, -1.599315926e-02, -2.946135402e-01, 5.770283937e-01, 4.774290621e-01, -4.122445825e-04, 3.171096444e-01, -5.226198435e-01, 7.703894973e-01, 9.753870368e-01, 2.565293014e-01, -2.352731973e-01, -1.231648996e-01, 3.153405190e-01, 3.109309971e-01, -1.077216506e+00, -6.796858311e-01, 2.518640459e-01, 2.552132905e-01, -1.720061451e-01, -1.293398261e+00, -2.393745333e-01, 3.481907845e-01, -3.032302856e-01, -2.846211791e-01, 2.723751664e-01, -2.223963588e-01, -1.813155413e-01};
real  W233[0:33] = {-8.137964457e-02, 2.716972828e-01, 4.533350170e-01, 1.953482330e-01, -2.330674678e-01, -1.662715971e-01, -1.960802972e-01, -2.620399930e-02, 2.403695434e-01, 5.370974913e-02, 7.773631215e-01, -6.492640376e-01, -6.066879258e-02, 4.369651675e-01, -5.705454350e-01, 1.171493903e-01, 5.599775910e-01, -1.970130950e-01, -2.275265306e-01, -2.861728668e-01, -8.985713720e-01, -4.324339926e-01, 3.405476734e-02, 5.421487615e-02, -3.440916911e-02, 5.168375373e-01, -8.711715937e-01, -7.551223785e-02, -5.004791617e-01, 6.427063048e-02, -6.363931298e-01, -9.126668572e-01, -9.560885839e-03, 3.450003862e-01};

real  B2[0:33] = {3.170010448e-01, -1.184024066e-01, -1.025252193e-01, -6.028895825e-02, 4.631375074e-01, -4.265453517e-01, 2.022177912e-03, 2.157851011e-01, -3.057763577e-01, -3.410107791e-01, -3.557533324e-01, -3.058205247e-01, -9.816413373e-02, -2.390275449e-01, 1.458421201e-01, -4.562152922e-01, -1.109672263e-01, 2.230737507e-01, 1.875338852e-01, 1.851684302e-01, -8.232145756e-02, 2.339810133e-01, -2.985370755e-01, -3.910605609e-01, 2.075020969e-01, -2.018669397e-01, 3.057188690e-01, 3.936374485e-01, -7.169476151e-02, 1.158784032e-01, 4.838813543e-01, 2.060759068e-01, -2.344178855e-01, -2.659822106e-01};
// --- OutputLayer ---
real  W30[0:0] = {-7.378352880e-01};
real  W31[0:0] = {8.315024376e-01};
real  W32[0:0] = {6.709334850e-01};
real  W33[0:0] = {-9.126505256e-01};
real  W34[0:0] = {-1.004271626e+00};
real  W35[0:0] = {1.219329596e+00};
real  W36[0:0] = {-4.663873017e-01};
real  W37[0:0] = {-1.055326462e+00};
real  W38[0:0] = {9.379523993e-01};
real  W39[0:0] = {1.621228814e+00};
real  W310[0:0] = {7.775261998e-01};
real  W311[0:0] = {1.018426538e+00};
real  W312[0:0] = {5.371984243e-01};
real  W313[0:0] = {6.693528295e-01};
real  W314[0:0] = {-6.590611339e-01};
real  W315[0:0] = {1.086785316e+00};
real  W316[0:0] = {1.067510486e+00};
real  W317[0:0] = {-1.078471422e+00};
real  W318[0:0] = {-9.555536509e-01};
real  W319[0:0] = {-1.002654791e+00};
real  W320[0:0] = {1.361393332e+00};
real  W321[0:0] = {-5.677582622e-01};
real  W322[0:0] = {-8.428106308e-01};
real  W323[0:0] = {1.020640373e+00};
real  W324[0:0] = {-1.057549715e+00};
real  W325[0:0] = {9.783548117e-01};
real  W326[0:0] = {-9.391354918e-01};
real  W327[0:0] = {-8.902637959e-01};
real  W328[0:0] = {-9.709826112e-01};
real  W329[0:0] = {-5.799222589e-01};
real  W330[0:0] = {-8.553452492e-01};
real  W331[0:0] = {-1.007903337e+00};
real  W332[0:0] = {8.629831672e-01};
real  W333[0:0] = {8.414413929e-01};

real  B3[0:0] = {-2.222472131e-01};
// --- HiddenLayer1 ---
real  Wlin00[0:34] = {-4.769933224e-02, 4.051388502e-01, -7.799759507e-01, 3.666160256e-02, 1.328705531e-02, -1.429271579e+00, 2.332466887e-03, -2.495558187e-02, -3.018754423e-01, -2.765094638e-01, 1.579482257e-01, -4.796335101e-02, -1.661018468e-02, -2.394076437e-01, 3.192863762e-01, -9.682993591e-02, 4.869436622e-01, -6.284592301e-02, 8.329041302e-02, -4.345062971e-01, -3.268753886e-01, 6.377534568e-02, 2.454987615e-01, 1.056473479e-01, 4.101845920e-01, 3.203139454e-02, 1.092721462e+00, -4.966560304e-01, -1.127636507e-01, 1.633129418e-01, -3.061873019e-01, -3.230176494e-02, 2.481131852e-01, -4.027315378e-01, 1.416646540e-01};
real  Wlin01[0:34] = {3.116176091e-02, -1.596842855e-01, 1.238934994e+00, 6.418269128e-02, -2.582484186e-01, 4.827854931e-01, -2.184895799e-02, 1.754682660e-01, 8.531042188e-02, -2.550356686e-01, 1.305986047e-01, 1.672372669e-01, -1.654763967e-01, 1.151400506e-01, -2.007524669e-01, -5.033320189e-02, -2.990534306e-01, -1.930554807e-01, -1.732683480e-01, -2.644541562e-01, -1.683675312e-02, 7.442644984e-02, 1.235878989e-01, 2.949355636e-03, 4.687339067e-01, -1.476281695e-02, -3.777454495e-01, -6.812073290e-02, 2.027979940e-01, 2.560859621e-01, 2.008827478e-01, -2.698322535e-01, -2.937611938e-01, -4.266457260e-02, -3.753137216e-02};
real  Wlin02[0:34] = {2.943785489e-01, 1.891786000e-03, 6.347424816e-03, 1.322198194e-02, -2.549383044e-01, 5.111765265e-01, -5.949399900e-03, -1.331686527e-01, -1.881389767e-01, 3.180142939e-01, -3.400412798e-01, 1.704864651e-01, -9.511970729e-02, 2.617145889e-02, 3.135621250e-01, 2.532593608e-01, 3.435987830e-01, -7.044174671e-01, 1.000130251e-01, 2.792289555e-01, -1.144018248e-01, 7.031743973e-02, -1.601862460e-01, -3.017267287e-01, -9.575198591e-02, 5.969218165e-02, -8.239703178e-01, 9.032739699e-02, 3.308164477e-01, -2.514272332e-01, -1.731072217e-01, -3.696550727e-01, 2.409823537e-01, -2.010383084e-02, -7.779877633e-02};

real  Blin0[0:34] = {2.535946667e-02, -5.108386874e-01, -2.790597379e-01, -2.008792013e-02, 2.926627100e-01, -1.152338460e-02, 3.661976010e-02, 7.874327153e-02, 1.499864608e-01, -2.770116925e-01, 1.331979334e-01, -7.836320996e-02, 8.509957790e-02, -2.346917838e-01, -1.476392597e-01, 8.020794392e-02, 1.703976840e-01, -6.721832752e-01, -1.064533088e-02, -3.828010261e-01, 2.851200402e-01, -3.874714673e-02, -3.290746808e-01, 6.909747422e-02, 1.339883506e-01, 7.851600647e-03, 4.841235280e-02, -5.314515233e-01, -4.236784279e-01, -2.542541921e-01, -1.700491011e-01, 1.864256412e-01, -1.100568548e-01, -2.371191233e-01, 2.498836517e-01};
// --- HiddenLayer2 ---
real  Wlin10[0:34] = {-2.307122350e-01, -1.498112231e-01, -3.319637105e-02, -1.189124212e-01, -1.869425476e-01, -1.417403072e-01, -1.069475338e-01, -1.444682181e-01, -1.556919664e-01, -6.693094224e-02, -1.302288175e-01, -1.044771597e-01, -1.418129802e-01, -5.323147029e-02, -3.323521316e-01, 2.892041765e-02, -1.915488839e-01, -1.002391204e-01, 4.386577904e-01, -3.263850510e-01, -2.065296024e-01, 2.560770884e-02, 9.997087717e-01, -1.386222839e-01, 2.274133563e-01, 1.841110364e-02, -3.423214555e-01, 2.290300280e-01, -5.518457852e-03, -1.736258119e-01, -4.757941142e-02, -2.624049485e-01, -4.719384909e-01, 2.027266175e-01, -1.766374260e-01};
real  Wlin11[0:34] = {1.771805249e-02, -4.071253836e-01, 1.781540662e-01, 3.788876534e-01, -4.455076158e-02, 4.106099010e-01, 3.125060201e-01, 6.941226870e-02, 6.713011861e-02, 1.102160513e-01, 3.490993083e-01, -1.522682756e-01, -7.196746022e-02, -9.154299647e-02, 1.991150677e-01, 1.989317536e-01, -2.541106045e-01, 3.571639061e-01, -9.180588126e-01, -2.440444939e-02, -2.208367735e-01, -1.101170480e-01, -1.025996879e-01, -4.463245273e-01, -8.645398617e-01, -1.529731750e-01, -1.525131166e-01, -4.646125436e-01, 3.262150884e-01, -1.835677922e-01, 1.384633631e-01, -2.512324154e-01, -5.846360326e-02, -2.744075060e-01, 1.146683376e-02};
real  Wlin12[0:34] = {4.433423653e-02, 4.689552262e-02, 4.110327661e-01, -4.461997002e-02, -6.521731615e-02, 1.784281284e-01, 1.976853758e-01, 1.764251441e-01, 1.572122723e-01, -5.066952109e-01, -1.098186336e-02, 3.093968034e-01, -5.654710904e-02, -2.716186643e-01, 4.245138764e-01, 1.804927289e-01, -1.154631674e-01, 2.446625233e-01, 2.142789215e-01, -2.686546743e-02, -2.528412938e-01, -1.761298776e-01, -4.796416163e-01, -1.441868842e-01, -2.632329166e-01, 8.196982741e-02, 3.066625893e-01, 9.617964029e-01, -7.471141815e-01, 3.926490247e-01, -2.801403105e-01, -3.706717491e-01, 1.825018078e-01, 6.176549941e-02, -9.894470125e-02};
real  Wlin13[0:34] = {7.741197012e-03, 1.377379149e-01, -7.898727059e-02, -7.677630335e-02, 1.483657658e-01, -2.954952717e-01, 2.806272209e-01, -5.863658339e-02, -2.281276584e-01, 1.877145171e-01, 3.303874731e-01, -1.602972597e-01, -7.081744075e-02, -3.495754302e-02, -8.246275038e-02, -1.794198714e-02, 2.516772449e-01, 1.346219778e-01, 3.997695446e-02, 2.423119694e-01, 1.363764554e-01, -5.717004184e-03, -4.434187710e-02, 1.097682342e-01, -1.552419215e-01, -1.978463829e-01, -5.928423628e-02, -2.779562473e-01, -4.321504235e-01, 3.510857522e-01, -8.080133796e-02, -1.578436792e-01, -8.664997667e-02, 2.422727495e-01, 6.617943197e-02};
real  Wlin14[0:34] = {-1.709961146e-01, 1.388661414e-01, 2.062235773e-01, -1.023369879e-01, -2.338833809e-01, 7.503724843e-02, 2.587227523e-01, -2.923695147e-01, -6.217970699e-02, -1.167704463e-01, -3.606912792e-01, -7.746812701e-02, 5.187087506e-02, 3.230312467e-01, 1.040979996e-01, 2.900865972e-01, -1.875042915e-01, -1.445156336e-01, -7.671315223e-02, -3.551959693e-01, 7.073094696e-02, -1.472159568e-02, -2.563589811e-01, -1.468306873e-02, 2.645935118e-01, -2.912726253e-02, 3.134727180e-01, -2.854621597e-02, 4.424496293e-01, 1.177824587e-01, 5.942994356e-02, 2.180168480e-01, 1.830968559e-01, 7.582805306e-02, 2.106009275e-01};
real  Wlin15[0:34] = {4.436538219e-01, -4.828541577e-01, 1.760305166e-01, 1.429649442e-01, -3.593984246e-02, 1.519336253e-01, 5.169176459e-01, -2.247232050e-01, 2.040477097e-01, 3.590900600e-01, -8.844018728e-02, -6.465701014e-02, 1.839132905e-01, -4.522394016e-02, 5.411025286e-01, 4.464141428e-01, -1.588712335e-01, 1.120004132e-01, -3.427507579e-01, -2.192199789e-02, 4.505007565e-01, 4.834536016e-01, -6.938306689e-01, -8.443296701e-02, -2.175730169e-01, 1.955292225e-01, 2.667288184e-01, -6.606493145e-02, 2.264357656e-01, 4.749650955e-01, 8.140518516e-02, -1.335912794e-01, 3.503712118e-01, -2.836669981e-01, 4.632150009e-02};
real  Wlin16[0:34] = {-1.517999321e-01, 1.598533988e-01, 1.975499392e-01, 1.372029632e-01, 8.472971618e-02, -1.756053790e-02, 5.743928254e-02, 4.038425982e-01, 4.631594419e-01, 2.445265800e-01, -2.331292480e-01, 4.346076399e-03, -1.476896405e-01, 8.897866309e-02, 3.484509885e-02, -1.562619060e-01, 4.211662412e-01, 1.470352560e-01, 8.646821976e-02, 1.667827517e-01, -9.332861751e-02, 5.036997423e-02, -8.746895939e-02, -1.577416062e-01, 1.187658608e-01, 1.795089096e-01, 2.189400606e-02, 5.305915140e-03, 3.687118739e-02, -1.512976885e-01, -1.870858297e-02, 2.962879241e-01, 2.355142981e-01, -2.401112020e-01, -1.258727312e-01};
real  Wlin17[0:34] = {3.546509519e-02, 2.221812755e-01, -1.514705271e-02, -1.009452268e-01, -1.213327795e-01, 7.830370218e-02, -2.533732951e-01, 2.417332977e-01, -2.617051303e-01, -1.123218164e-01, -1.330705136e-01, -2.076751441e-01, 1.164120659e-01, 1.761711538e-01, 4.506355617e-03, -4.352670908e-02, 7.235961407e-02, -4.790714011e-02, 7.990040630e-02, -3.950275481e-03, 3.812956065e-02, -1.940455139e-01, -1.083084270e-01, -2.596337497e-01, -2.454249412e-01, -2.285271436e-01, -1.446139961e-01, -1.650194526e-01, -4.534177184e-01, 3.094467223e-01, 2.286747657e-02, 3.714505211e-02, 1.222614348e-01, -1.048125476e-01, -2.180584520e-01};
real  Wlin18[0:34] = {7.285025716e-02, 8.949404955e-02, -1.243726537e-01, -8.678027242e-02, -4.677474126e-02, 1.477187723e-01, -6.234038994e-02, 2.192431092e-01, -4.719058424e-02, 3.125842214e-01, -9.417165816e-02, -7.983033359e-02, 4.432093352e-02, 1.776321083e-01, -3.567215204e-01, -3.204895929e-02, 1.878935546e-01, 3.053626716e-01, 3.184576929e-01, -1.010622978e-01, -1.836518645e-01, -2.440895587e-01, -5.141096190e-02, -1.059463173e-01, 5.824387074e-01, 9.485125542e-02, -1.898396611e-01, 3.461030722e-01, -7.368819416e-02, -1.446239948e-01, 8.879893273e-02, 3.629764020e-01, 2.013794146e-02, -4.255467281e-02, -1.895840168e-01};
real  Wlin19[0:34] = {1.190469489e-01, 1.809535027e-01, -1.226225682e-02, 2.442439198e-01, -2.348762751e-01, -1.240545064e-01, -4.187678173e-02, 1.273675114e-01, 1.306475401e-01, 9.690167755e-02, 2.974043190e-01, 1.165740788e-01, 9.324745834e-02, -1.796682179e-01, -3.462204635e-01, 1.446439326e-01, -2.578015924e-01, -2.684501708e-01, 2.112232707e-02, -2.344560064e-02, -2.216996849e-01, 1.284136772e-01, 8.388170600e-01, 1.269318908e-01, 2.627490163e-01, 1.285001934e-01, 3.565165773e-02, -2.862744629e-01, -3.957569972e-02, -3.391577005e-01, 1.712636948e-01, -3.284660578e-01, 3.235616535e-02, 1.610137522e-01, 2.927795649e-01};
real  Wlin110[0:34] = {-7.047112286e-02, -4.273080826e-02, 1.566891074e-01, -3.331431150e-01, -1.167257801e-01, -1.553424597e-01, 2.263063192e-01, 4.026895389e-02, -3.215338662e-02, 2.020228654e-01, -1.099288464e-01, 1.914761961e-02, -2.134783380e-02, 1.082277894e-01, 3.815511465e-01, 1.151523963e-01, 2.465478927e-01, -1.801351458e-01, 1.621098369e-01, 3.865564167e-01, -9.153174236e-03, -1.895632595e-01, -1.249650598e+00, -2.046063542e-01, -1.528033018e-01, 4.126855358e-02, 1.316037327e-01, 6.701803952e-02, -2.700687647e-01, 3.503997624e-01, 1.390785575e-01, -9.433391690e-02, 3.791219890e-01, -1.215804443e-01, -3.109886050e-01};
real  Wlin111[0:34] = {-2.155776620e-01, 2.509471774e-02, -2.704659104e-01, -4.718871042e-02, 1.609799564e-01, 9.797672927e-02, -2.954437733e-01, 1.604521722e-01, -1.942955106e-01, -1.724542081e-01, 1.930721849e-02, -2.592417598e-02, -1.752862334e-01, -2.839721739e-01, -1.081024949e-02, 8.292888105e-02, 1.972935349e-02, 1.090084314e-01, 3.987570405e-01, -1.636643112e-01, -1.653734148e-01, -2.503317893e-01, 3.008243144e-01, 2.144961357e-01, 8.083195984e-02, 6.589533389e-02, -4.753986746e-02, -1.505325437e-01, -3.790805936e-01, -2.283727080e-01, -2.457859963e-01, -2.499032170e-01, -3.307443857e-01, 5.362255499e-02, -1.051696688e-01};
real  Wlin112[0:34] = {1.954007000e-01, 2.438591570e-01, 1.839613318e-01, -1.954636909e-02, 2.158535272e-01, -8.145510405e-02, 9.776695818e-02, -2.909047008e-01, 1.769182682e-01, 3.014004417e-02, 1.843971387e-02, -1.253185272e-01, 1.399186701e-01, 2.744242549e-01, -1.489750594e-01, 1.084480360e-01, 2.348368615e-01, 8.456949145e-03, -9.159386903e-02, 1.757524908e-01, -2.067829967e-01, 4.364884645e-02, -3.311094046e-01, 2.549859583e-01, 3.691661656e-01, 1.257515401e-01, -9.985972196e-02, -3.308984935e-01, 6.122619510e-01, 2.345796116e-02, -2.083278447e-01, 9.623105824e-02, 2.322662771e-01, -2.882736623e-01, -1.136169285e-01};
real  Wlin113[0:34] = {5.632022023e-02, 1.657859981e-01, -1.645376831e-01, -1.562231034e-01, -2.770831585e-01, -1.697616726e-01, -2.089885324e-01, -1.321558058e-01, -1.306372508e-02, 1.855806820e-02, 4.356590509e-01, 5.370992422e-02, -4.435395822e-02, -3.415891230e-01, -1.526609659e-01, -3.669986129e-01, -7.176087797e-02, -8.484724164e-02, -1.008365601e-01, 9.093556553e-02, -6.309553385e-01, -1.630941778e-01, 4.522132874e-01, -5.681004748e-02, -7.725672331e-03, 1.933535561e-02, 1.657030880e-01, -7.881131768e-02, -3.631006181e-01, -3.923089430e-02, 7.746414840e-02, -3.127888739e-01, -3.020156622e-01, 2.688750923e-01, 2.081678957e-01};
real  Wlin114[0:34] = {6.095949933e-02, 1.572707146e-01, 6.443053484e-02, 3.108956618e-03, -3.721099198e-01, -1.317506284e-01, -3.029679134e-02, -2.449212372e-01, 1.807092279e-01, -4.106613398e-01, -1.862045527e-01, -1.294530276e-02, -1.156116202e-01, -1.293181479e-01, 9.377833456e-02, 1.400975138e-01, -2.259084955e-02, 3.046905808e-02, -2.261437029e-01, 4.821309075e-02, -3.378157690e-02, 1.461469382e-01, -9.901975840e-02, -3.924259916e-02, -5.249115825e-01, 9.251796454e-02, 4.218979776e-01, -4.102900326e-01, 3.771951199e-01, 1.910750717e-01, -5.833408982e-02, -3.239278793e-01, 2.142070234e-01, -6.408563256e-02, -1.984543651e-01};
real  Wlin115[0:34] = {-2.014160622e-03, -2.818744071e-02, -6.136220321e-02, 1.694255918e-01, -1.238568872e-01, 1.532386690e-01, -2.285782695e-01, 1.280043423e-01, -3.441099823e-01, 9.795847582e-04, -5.192676932e-02, -2.976499200e-01, -2.124084085e-01, -1.470336318e-01, -3.726714551e-01, -5.085437745e-02, 1.696324646e-01, -1.958544701e-01, 4.405976534e-01, -2.461072616e-02, 7.004922628e-02, 2.229152173e-01, 6.189223528e-01, 1.877696961e-01, 2.969516218e-01, -3.386108205e-02, -2.539087832e-01, -2.564242482e-01, -4.191296548e-02, -1.151107997e-01, 1.343742106e-02, -3.121433556e-01, -1.987047493e-01, 1.058902815e-01, -4.137101397e-02};
real  Wlin116[0:34] = {-7.934973389e-02, -9.880480170e-02, -2.771323025e-01, -1.147193089e-01, 2.958829328e-02, 2.558488250e-01, 2.177732885e-01, 1.239700615e-02, -8.638300002e-02, 6.879201531e-02, -4.187190831e-01, 3.034734726e-02, 1.307476759e-01, 9.018047899e-02, -9.869687259e-02, 2.552679367e-02, 2.298094332e-01, -1.399080902e-01, -6.072004512e-02, -4.420783743e-02, 4.330728948e-01, 3.959051371e-01, 4.331438337e-03, 4.609534889e-02, -3.648384213e-01, -2.943066880e-02, 1.108572483e-01, -5.378301740e-01, 8.658830523e-01, 3.482170999e-01, 1.203015447e-01, -8.519694209e-02, 2.057575621e-02, -1.912727356e-01, -4.352781177e-02};
real  Wlin117[0:34] = {-1.923557818e-01, 9.187620133e-02, 1.891001761e-01, -1.422953606e-01, 1.889810711e-01, -2.705497444e-01, -1.855777502e-01, -3.913490102e-02, -1.627538949e-01, 8.695457131e-02, 1.576665342e-01, -1.006120369e-01, -1.720327139e-01, -8.591937274e-02, -2.417483367e-02, -8.814112842e-02, -1.200457569e-02, 3.005746007e-02, -1.924851984e-01, 1.623732597e-01, -5.075663924e-01, 1.112267599e-01, -8.514713645e-01, 1.391525269e-01, -3.864296973e-01, 9.051480889e-02, 1.390295178e-01, -4.773145318e-01, 3.086605966e-01, 2.209119648e-01, 4.829265177e-02, -2.821648717e-01, 2.703331783e-02, 1.644266993e-01, -2.282089442e-01};
real  Wlin118[0:34] = {2.396888733e-01, -2.945220470e-01, -2.140489072e-01, 2.833333015e-01, -9.575515240e-02, 1.691407859e-01, 2.479254035e-03, -3.665816411e-02, -2.699683607e-02, -8.815120161e-02, 9.383387119e-02, -3.867172450e-02, 2.885231972e-01, -5.065025389e-02, -3.104940616e-02, -2.407818884e-01, 1.297216564e-01, 2.901114523e-01, -7.050026953e-02, 8.369141072e-02, 1.705920249e-01, -6.286192220e-03, 2.091331184e-01, -3.233179748e-01, -2.609835863e-01, 4.067656696e-01, 2.520031668e-02, -3.758137226e-01, 5.391877890e-01, -1.867142320e-01, -1.101879701e-01, -1.770929396e-01, 6.318929791e-02, -8.317109197e-02, 1.591108143e-01};
real  Wlin119[0:34] = {-2.301627398e-01, 2.703354657e-01, 2.429171354e-01, -4.619413242e-02, 2.596468329e-01, 2.646597624e-01, 4.187517241e-02, 1.055275649e-01, 1.173116453e-02, -2.503534555e-01, 2.416028827e-01, -1.178900450e-01, 3.528621420e-02, -4.555896819e-01, -4.406359196e-01, -1.708996445e-01, 2.925938070e-01, -1.228130329e-02, -2.390588671e-01, 3.560801223e-02, -6.171001792e-01, -1.920107752e-01, 1.081272721e+00, -7.241173834e-02, -1.287017763e-01, 6.675828993e-02, -3.040429354e-01, -2.017667145e-01, 1.740527898e-01, -3.783084452e-01, -1.516811848e-01, 2.005852461e-01, -6.082194671e-02, -1.553954780e-01, 8.891616762e-02};
real  Wlin120[0:34] = {-3.243041039e-01, 4.683317989e-02, -4.999775887e-01, 1.819524914e-02, -1.777628511e-01, -2.041564286e-01, -1.526831985e-01, 3.187168762e-02, -1.336580664e-01, 1.060354635e-01, -1.688070893e-01, 7.078120857e-02, 3.301800042e-02, 2.404320389e-01, -2.549234331e-01, -3.898380399e-01, -6.025198475e-02, -1.855781078e-01, 2.547892332e-01, -2.317092940e-02, 1.067293733e-01, -4.604150727e-02, 2.332317382e-01, 3.616659045e-01, 5.113186240e-01, -1.107957438e-01, 1.102672443e-01, 1.483096927e-01, 2.550897561e-02, -1.316004097e-01, -1.668374687e-01, 4.706298932e-02, -3.102545142e-01, -1.389153451e-01, 3.521168828e-01};
real  Wlin121[0:34] = {2.064242512e-01, 3.629077226e-02, 1.381994784e-01, 1.029118821e-01, 8.028622717e-02, -3.248089850e-01, 3.226222098e-02, -9.023925290e-03, -4.498170316e-01, 1.666544676e-01, -9.309104830e-02, 1.126094908e-01, -3.166896477e-02, -2.174405158e-01, -9.591563791e-02, 7.439114898e-02, 2.096705139e-01, 8.576766402e-02, 1.375258714e-01, -1.442856789e-01, 3.219965100e-02, -1.216342375e-01, 2.423746884e-01, 2.653216124e-01, -3.634136021e-01, 2.176011801e-01, 1.726892143e-01, -1.930621564e-01, -2.113436311e-01, 2.232327014e-01, -2.187247425e-01, -8.292476088e-02, 1.847833693e-01, 3.152446151e-01, 9.508243203e-02};
real  Wlin122[0:34] = {6.616234034e-02, -1.369897872e-01, 2.789236903e-01, -1.066494212e-01, 2.718915343e-01, -1.192243323e-01, 3.251226544e-01, 1.343363523e-01, 1.638561338e-01, 7.664943486e-02, 1.463629156e-01, 3.020068817e-02, 1.025424004e-01, -2.600692213e-01, 1.190297604e-01, 5.796359479e-02, -1.796521246e-01, 2.328987420e-01, -6.763320565e-01, -2.563140392e-01, 3.441248089e-02, 4.202837124e-02, -2.727612555e-01, -2.593694329e-01, -7.003715634e-01, 7.309238613e-02, 8.167969994e-03, -5.602622405e-02, 6.006153300e-02, 1.893168390e-01, -1.069874540e-01, -3.980529606e-01, 1.720970720e-01, 5.428905599e-03, -2.245697230e-01};
real  Wlin123[0:34] = {2.003968060e-01, -2.685076594e-01, 2.731219530e-01, 1.161972061e-02, 1.094568521e-01, -1.442348510e-01, 7.642353885e-03, -1.076840684e-01, 1.367371976e-01, -2.787874639e-01, -2.413567156e-01, -4.285112396e-02, -2.058294266e-01, 3.121814132e-01, 1.214114204e-02, 1.783160716e-01, 9.262438118e-02, -1.480921805e-01, -3.605536520e-01, -2.511084080e-01, 1.250536442e-01, -4.204264283e-02, -1.217602968e+00, 1.118608564e-01, 2.344460040e-02, 9.733204544e-02, 3.235203922e-01, 3.135179579e-01, -1.496999264e-01, 2.523543835e-01, -8.465089649e-02, 2.281129807e-01, 3.258569539e-01, -2.150906771e-01, 2.440832369e-02};
real  Wlin124[0:34] = {-5.774118938e-03, 1.625178456e-01, -5.206719786e-02, -1.606421620e-01, 1.398961432e-02, -1.010511741e-01, 1.662236452e-01, -1.544184834e-01, 1.975017786e-01, 2.355441302e-01, -2.496948987e-01, -3.157695234e-01, 4.391804039e-01, 1.231553927e-01, 7.254512608e-02, 7.278446108e-02, 1.031423807e-01, -2.993217409e-01, -1.625152826e-01, -1.235777214e-01, 1.021381281e-02, 2.328542769e-01, -2.146238238e-01, 3.354808688e-01, -2.227151692e-01, 2.874231637e-01, -9.594048560e-02, -2.294240892e-01, -2.747942209e-01, 3.323663473e-01, -2.575156391e-01, -1.402186900e-01, 9.318985790e-02, -6.111987308e-02, 2.725387216e-01};
real  Wlin125[0:34] = {3.167208135e-01, 2.270954847e-01, 1.845003366e-01, 2.000849135e-02, -1.729920506e-01, 2.864760906e-02, 1.835891046e-02, 3.068374395e-01, -5.267938226e-02, 2.162268311e-01, -2.296019495e-01, 1.834497750e-01, -1.951764375e-01, 1.982667893e-01, -1.631681435e-02, -2.219962887e-02, -1.515924782e-01, 2.413675487e-01, 2.265402377e-01, -1.252144277e-01, -1.385490149e-01, 1.565827057e-02, 4.156862199e-01, -1.254174262e-01, -1.010167077e-01, 1.557775736e-01, 8.615416475e-03, -1.909237504e-01, -5.683284625e-02, 1.437666453e-02, -8.031423390e-02, -9.926599264e-02, 1.627216637e-01, -1.867247969e-01, 6.247900426e-03};
real  Wlin126[0:34] = {5.372766033e-02, 2.493553013e-01, -4.541278183e-01, -1.224484742e-01, -9.063418955e-02, 6.558489799e-02, -3.198873997e-01, 3.468129039e-01, -2.445605397e-01, 2.983789518e-02, 3.089451194e-01, 1.217214018e-01, 1.887775809e-01, -4.268364608e-02, -1.508464962e-01, -8.004070818e-02, 2.171251774e-01, -3.204643726e-01, 1.036129445e-01, 2.517635375e-02, -1.824412048e-01, -2.489066422e-01, 8.390982449e-02, 3.225545585e-01, 1.911006123e-01, 1.391269565e-01, -3.432535529e-01, 4.801957011e-01, -7.349833846e-02, -2.215215564e-01, -1.640138179e-01, -2.607292235e-01, -7.399273105e-03, 3.518105447e-01, 3.486878574e-01};
real  Wlin127[0:34] = {-2.978627756e-02, -3.801589133e-03, 2.441123500e-02, 4.944465756e-01, 4.452228174e-02, 2.326136529e-01, -1.600314379e-01, 2.947302759e-01, 2.243860066e-01, 6.988210976e-02, 7.988368869e-01, -2.503656745e-01, 2.557953000e-01, -6.542635560e-01, 1.170872003e-01, -1.531571746e-01, 3.737879097e-01, -1.386300474e-01, -7.572598755e-02, -5.019120872e-02, -1.166720867e+00, -4.572788775e-01, 6.554068923e-01, 1.248444542e-01, -2.433763742e-01, -2.831163406e-01, -3.491179049e-01, 3.239398077e-02, 1.049128622e-01, -3.119831979e-01, -2.601667941e-01, -2.777118981e-01, 6.987227499e-02, 4.016051888e-01, -6.576808542e-02};
real  Wlin128[0:34] = {-2.985303104e-01, 1.473024786e-01, 4.102914780e-02, 1.317913532e-01, 4.814753681e-02, 8.311904222e-02, -1.044148505e-01, 3.252330124e-01, -1.980162859e-01, 2.645729482e-01, 6.728737354e-01, -2.716383338e-01, 1.598831117e-01, -3.814134598e-01, -3.408733010e-01, 1.312362403e-01, 2.608748674e-01, -1.231447607e-01, -5.643431097e-02, -2.490649372e-02, -7.552888989e-01, -1.400427669e-01, 9.546177387e-01, 3.835016191e-01, -3.621465713e-02, 1.210942566e-01, 5.709230527e-02, 7.085139304e-02, -2.093424648e-01, -4.101713896e-01, -1.387154907e-01, -5.525180101e-01, -3.776484430e-01, -1.194435656e-01, 1.095557958e-01};
real  Wlin129[0:34] = {1.273774058e-01, -3.561252356e-02, 4.745919630e-02, -1.037088558e-01, -3.737518489e-01, -1.083458066e-01, -1.066942066e-01, 2.729058033e-03, -5.341358017e-03, -7.055074722e-02, -2.674104273e-02, -9.028263390e-02, -5.279042572e-02, -1.480713487e-01, 2.650394440e-01, -4.000497865e-04, -2.273406833e-01, 7.861097902e-02, -4.558999538e-01, -2.907034755e-01, -1.152411103e-01, 1.816773862e-01, -3.832016587e-01, -2.225262433e-04, -5.817067623e-01, -1.369367093e-01, -1.186003312e-01, -2.674150765e-01, 1.088020653e-01, -1.585821509e-01, 6.327292882e-03, -2.129239291e-01, 3.903455138e-01, -3.259978592e-01, 2.623979002e-02};
real  Wlin130[0:34] = {-2.619718015e-01, 2.533199787e-01, 2.272099704e-01, -1.205507070e-01, -7.093574852e-02, -2.538782358e-01, 3.191247582e-02, 1.680167168e-01, -2.829335630e-01, 2.206366695e-02, 4.475170076e-01, 1.085746475e-02, 1.386045758e-02, 1.007701531e-01, -1.372632533e-01, 2.410932481e-01, 2.538067102e-01, -2.800792456e-01, 1.064295322e-01, -1.369891465e-01, -4.016538262e-01, -6.172193214e-02, 2.169881016e-01, -9.883062541e-02, 1.602662057e-01, -1.140368357e-01, -2.202702612e-01, 3.452972043e-03, -3.901047409e-01, -1.862631291e-01, 8.215989918e-02, 2.538220286e-01, 1.145496592e-01, -4.548771773e-03, -3.316061944e-02};
real  Wlin131[0:34] = {1.999183148e-01, -2.206826657e-01, 1.934505403e-01, -1.973526031e-01, -3.604722917e-01, 2.896442413e-01, 3.054072261e-01, -2.177737094e-02, 4.940966517e-02, -1.439170986e-01, -3.175348639e-01, -6.118491665e-02, 7.496163994e-02, 1.166367605e-01, -7.518111914e-02, 7.282266766e-02, -2.819979489e-01, 2.034642696e-01, -8.426323533e-02, -3.563475311e-01, 2.487469316e-01, 3.431113958e-01, -1.082664847e+00, 1.457233876e-01, -1.005597785e-01, 2.094376981e-01, 1.510900855e-01, -2.417684644e-01, 5.371633768e-01, 2.709904015e-01, 2.859835327e-01, 1.212418228e-01, 4.212773964e-02, -4.425365105e-02, 5.848446488e-02};
real  Wlin132[0:34] = {8.258763701e-02, 2.398834005e-02, 1.433494538e-01, 1.840056926e-01, -5.041702092e-02, 1.715904325e-01, 2.198041230e-01, 1.226742342e-01, 7.937934995e-02, 2.054294795e-01, -2.104996592e-01, 1.659147590e-01, 1.065550074e-01, 1.181385666e-01, 4.007838294e-02, 2.020515800e-01, -7.047784049e-03, 2.100025304e-02, -3.241104782e-01, -2.955577374e-01, -5.685489997e-02, 9.476104751e-03, 7.891377062e-02, -3.011491150e-02, -1.088640839e-01, -1.090555638e-01, 2.267496139e-01, -3.878198564e-01, 6.737728715e-01, -4.943173751e-02, 1.661132425e-01, -3.987092376e-01, -8.308459818e-02, -2.262679338e-01, 8.857343346e-02};
real  Wlin133[0:34] = {3.295494616e-02, 2.987481654e-01, 1.003437340e-01, 4.692864791e-02, 1.107324585e-01, -1.442966610e-01, -2.653221190e-01, 1.677061021e-01, -2.551318407e-01, -2.629250288e-01, -8.408739232e-03, 1.481199712e-01, 8.861832321e-02, -1.130796298e-01, -4.149217904e-01, -2.339100540e-01, 1.852660775e-01, -2.469318658e-01, -2.483792305e-01, -1.314997822e-01, -6.440420747e-01, -3.551949263e-01, 2.430868447e-01, -1.511846017e-02, 2.142102569e-01, 2.331270725e-01, -1.589138657e-01, 3.024109304e-01, 4.995870218e-02, -7.959239185e-02, -7.770834118e-02, -8.038786799e-02, 1.968398988e-01, -1.684108973e-01, -1.048287526e-01};
real  Wlin134[0:34] = {-1.648969352e-01, 1.553889066e-01, 2.621679008e-01, -1.497287489e-02, 3.692929447e-01, 4.437509552e-02, -1.543679386e-01, 1.290301681e-01, 1.436922550e-01, -2.742345035e-01, -2.123765945e-01, -5.012675747e-02, 1.898509823e-02, -2.954712696e-02, 2.250169069e-01, 1.447756439e-01, 2.200593948e-01, 2.880401313e-01, 8.713366091e-02, 5.424028262e-02, 4.611383379e-01, 7.954470068e-02, 7.902168669e-03, -3.343569636e-01, -1.355246007e-01, -2.731662802e-02, -9.313750267e-02, -1.366566867e-01, -1.441683322e-01, 1.970103830e-01, -5.571582913e-02, -7.091318071e-02, 1.519423574e-01, 2.635923624e-01, -1.623022556e-01};

real  Blin1[0:34] = {-5.440960824e-02, 1.417264640e-01, -2.602915168e-01, -1.978280097e-01, 9.768061340e-02, -2.632971294e-02, -1.219904870e-01, 1.237049699e-01, -2.470818721e-02, 4.450796172e-02, -2.391635180e-01, -1.246856451e-01, 1.506214496e-02, 1.960391551e-01, -8.173085749e-02, -1.083660573e-01, 3.148448886e-03, 1.271328516e-02, 2.979516387e-01, -4.749954492e-02, 5.604327321e-01, -1.621023193e-02, 7.551430911e-02, -9.206715971e-02, 2.619096041e-01, -4.113679379e-02, -1.005587429e-01, 5.878700688e-02, -4.435789958e-02, 1.531898826e-01, -5.663882941e-02, 3.021025360e-01, -8.741872758e-02, 6.810351461e-02, -1.401441055e-03};
// --- HiddenLayer3 ---
real  Wlin20[0:34] = {9.018805623e-02, 1.728329062e-01, -1.561064273e-01, 6.867530197e-02, 7.538668811e-02, 1.976218522e-01, 2.913267724e-02, -4.830046743e-02, 1.988064051e-01, 7.081364840e-02, -1.341898441e-01, 3.481301963e-01, 1.465992182e-01, -1.603432298e-01, 2.547055185e-01, -1.170560047e-01, 1.428670138e-01, -1.169163883e-01, -6.551596522e-02, 7.813500613e-02, 5.777176842e-02, -5.824944470e-03, -2.472907007e-01, 1.378478408e-01, -2.178763300e-01, 8.030679077e-02, 1.094196178e-02, 1.040097028e-01, -2.263143472e-02, 3.964284435e-02, -2.258903831e-01, 2.289411053e-02, -2.225057185e-01, -7.178003341e-02, 2.666047812e-01};
real  Wlin21[0:34] = {-1.775723696e-01, 1.753486991e-01, 2.729604542e-01, 2.997016609e-01, -1.402918398e-01, 3.355167061e-02, -7.610973436e-03, 5.346447229e-02, -3.211207315e-02, 4.360658675e-02, -4.619508609e-02, -1.533726305e-01, 1.043190509e-01, -3.174030483e-01, 1.404148042e-01, 1.066549420e-01, 5.342526734e-02, -2.010904066e-02, 6.413924694e-02, 3.691335320e-01, 1.278518736e-01, -1.130581573e-01, -1.137772501e-01, 2.027081996e-01, 1.677263826e-01, -1.945065409e-01, 3.638994992e-01, 6.661921740e-02, 7.378532737e-02, 2.156516016e-01, -3.267814219e-02, -1.122961789e-01, 2.592947185e-01, 9.182623774e-02, -2.928777635e-01};
real  Wlin22[0:34] = {-7.390590012e-02, 1.964371949e-01, -8.182316273e-02, -2.691484392e-01, -3.554799408e-02, -8.680366725e-02, -8.739096671e-02, 3.578706644e-03, 3.468995690e-01, 6.498267874e-03, 3.613670766e-01, 2.167863101e-01, 1.844381094e-01, -8.235346526e-02, -3.718350455e-02, -7.688417286e-02, 6.242255867e-02, 1.067710668e-01, -2.341769934e-01, -2.393683344e-01, 1.446686387e-01, -4.786231518e-01, 1.247803792e-01, 3.568780050e-02, -1.379878223e-01, 1.009778380e-01, -3.336377144e-01, -1.370487511e-01, 5.364329740e-02, 9.277245402e-02, 2.367800623e-01, 2.385875732e-01, -2.460025102e-01, 7.367284503e-03, -7.455636747e-03};
real  Wlin23[0:34] = {2.282278612e-03, -8.547274768e-02, -1.609202921e-01, -2.595216967e-02, -1.903769374e-02, -1.222302672e-02, -6.599005312e-02, 3.245165646e-01, 1.471293718e-01, 1.653527766e-01, -8.398535848e-02, -2.307613343e-01, -4.041676223e-02, 1.455788165e-01, -2.631212771e-01, -7.776762545e-02, -7.631734479e-03, 2.070152909e-01, -6.601019762e-03, 3.117178380e-01, -1.938562095e-01, -1.168291047e-01, -3.434530199e-01, 1.049174070e-01, 1.881972551e-01, -1.356184483e-01, -2.163424506e-04, 1.507734805e-01, -2.576710284e-01, 2.677570581e-01, 2.351643890e-01, 1.911843717e-01, 4.521602392e-01, 6.184441596e-02, -1.453063190e-01};
real  Wlin24[0:34] = {-1.292137057e-01, -3.769806772e-02, 1.596342325e-01, 4.494675621e-02, 6.740347296e-02, -1.194230244e-01, -2.177960239e-02, -7.374539971e-02, -3.183377162e-02, 1.042791754e-01, -2.207055241e-01, -1.197615871e-03, -9.055056423e-02, -1.209764928e-01, -7.053747773e-02, 3.111105561e-01, -3.708984877e-05, -1.006267071e-01, 2.755897045e-01, -1.531909704e-01, 6.399057806e-02, -1.082274467e-01, -3.738659667e-03, 3.697050363e-02, -1.955177868e-03, -5.702385306e-02, 3.863465488e-01, 7.269066572e-02, -1.012043729e-01, 1.121247336e-01, 1.550068706e-01, -1.113306731e-01, 3.447532654e-02, 1.156688109e-01, -6.476457417e-02};
real  Wlin25[0:34] = {7.549036294e-02, 1.094291732e-02, -2.228502631e-01, -1.148395687e-01, -6.794407964e-02, -1.812408566e-01, -1.824775338e-01, -2.397003621e-01, -7.390416414e-02, -9.174171835e-02, -3.468268514e-01, -3.257300556e-01, 1.362388488e-03, -1.610643417e-01, 1.274270564e-01, -1.988211274e-01, -1.768324375e-01, 1.218909845e-01, 1.006352454e-01, 2.084163278e-01, 5.601946637e-02, 1.781337559e-01, -1.116680913e-03, 4.709186405e-02, -4.889241233e-02, -6.596602499e-02, -1.657956541e-01, 1.054205596e-01, -2.383045703e-01, 1.071075425e-01, 8.868560940e-02, -8.386886120e-02, 2.158066630e-01, 9.577011317e-02, -3.988195583e-02};
real  Wlin26[0:34] = {2.026443779e-01, -3.036988378e-01, -2.882842422e-01, -1.481371820e-01, 8.837477863e-02, -7.706071436e-02, 1.175501123e-01, 1.421995014e-01, 3.942913413e-01, -2.287575305e-01, -5.329236984e-01, 1.277800053e-01, -1.875945777e-01, -1.500461847e-01, 1.015020013e-01, -1.086685881e-01, -1.800705343e-01, -3.041122556e-01, 2.537390888e-01, -3.966138661e-01, -1.894264370e-01, 7.401669025e-02, -2.399558425e-01, -1.461156160e-01, 2.074956000e-01, 3.590524495e-01, -3.550163209e-01, 5.332134664e-02, 2.718157768e-01, -3.128629327e-01, -7.256514579e-02, 4.733411968e-02, -1.722433567e-01, -4.937574640e-02, -2.331997454e-01};
real  Wlin27[0:34] = {3.019850254e-01, -1.690200064e-03, 8.406097069e-03, -2.299854904e-01, 1.419818215e-02, -2.964033484e-01, 1.696013063e-01, -2.118670195e-02, -2.192015052e-01, 5.184250697e-02, -5.663685501e-02, -2.632567585e-01, 1.071398240e-02, 6.731010228e-02, -8.210954815e-02, 3.321713805e-01, 1.720772833e-01, 1.129308119e-01, -1.275620013e-01, -1.664371416e-02, 2.244319171e-01, -9.980184585e-02, -1.137941480e-01, -2.093860358e-01, 2.003852427e-01, -2.580591142e-01, 1.487007439e-01, 1.820446923e-02, 2.051570863e-01, 1.932225078e-01, 1.182899252e-01, -4.098531324e-03, 1.900540292e-01, -4.546871781e-02, 7.088479400e-02};
real  Wlin28[0:34] = {1.050032079e-01, -8.530186024e-04, 7.574813068e-02, -2.112551481e-01, -5.854839925e-03, -1.584722847e-02, 1.160741150e-01, -1.137208492e-01, 3.299762309e-02, -2.362560108e-02, -1.181315780e-01, 3.068354540e-02, 4.995290935e-02, 9.359775484e-02, 1.231733244e-02, -2.506883740e-01, -1.761580002e-03, 9.344540536e-02, -2.698892653e-01, -2.398610115e-01, 8.051716536e-02, -6.287405640e-02, -7.463930547e-02, 1.048603952e-01, 1.543285996e-01, -3.090189584e-02, -5.967109278e-02, 2.421520799e-01, 3.534091413e-01, -4.025472105e-01, 4.375931807e-03, 3.392869234e-02, 9.867843986e-02, 1.030654386e-01, 1.741767973e-01};
real  Wlin29[0:34] = {-1.465794742e-01, -2.351107895e-01, -6.516934931e-02, 3.336901069e-01, -1.199075654e-01, 2.415830735e-03, 3.027490526e-02, 9.157363325e-02, 3.874602541e-02, -5.310816690e-02, -1.093976721e-01, -5.198666826e-03, -5.193452165e-02, -3.168371320e-02, -3.035312146e-02, 1.322167665e-01, -4.096283019e-02, -4.671327397e-02, 1.135152727e-01, 3.621234298e-01, -1.652318984e-01, 1.977860183e-01, 6.330096722e-02, 1.187200751e-02, -8.811611682e-02, 3.957096487e-02, 6.033046544e-02, 2.644459605e-01, -2.905097902e-01, -2.283510119e-01, 1.614555418e-01, -8.453906327e-02, 3.580719605e-02, -3.706561401e-02, 1.832864434e-01};
real  Wlin210[0:34] = {7.642770559e-02, 2.834206820e-01, 3.336442411e-01, -3.027877510e-01, -2.046605106e-03, -1.506979614e-01, 4.479304329e-02, 1.684455946e-02, -1.461915020e-02, 7.458135486e-02, -1.771690696e-02, -4.380300343e-01, -5.269474536e-02, -1.235570014e-01, 7.667484134e-02, 5.847609043e-01, -2.036606222e-01, -2.600278854e-01, -6.297032237e-01, 2.728563845e-01, 1.737197340e-01, 2.602843940e-02, -3.816559613e-01, -1.550571434e-02, 1.311466992e-01, -2.540207207e-01, -4.270607531e-01, 9.396543354e-02, -7.644608617e-02, -1.448342227e-03, 2.550538778e-01, 4.395956695e-01, 2.899073660e-01, 3.024966121e-01, 2.949028909e-01};
real  Wlin211[0:34] = {-2.710616589e-01, 6.106114760e-02, 1.560906619e-01, -1.864855587e-01, 1.437970102e-01, 7.237084955e-02, -7.693100721e-02, 1.193122789e-01, -1.257230192e-01, 1.429188102e-01, 1.173409894e-01, 1.822816133e-01, 6.032366306e-02, -1.298418045e-01, -1.233121101e-02, -1.984369457e-01, -7.916459441e-02, 2.026451081e-01, -2.008186877e-01, -1.542163044e-01, 5.670576915e-02, -7.030101120e-02, -1.841998249e-01, 4.500494525e-02, -1.787216030e-02, 1.035974547e-02, -1.300873160e-01, -1.177581027e-01, 3.618058562e-01, 4.653319716e-01, 6.095740944e-03, 5.561956391e-02, -1.008884907e-01, 8.628129214e-02, -1.961579919e-01};
real  Wlin212[0:34] = {-1.874992698e-01, -1.173077617e-02, -3.321071267e-01, 1.739131100e-02, 9.755040705e-02, 3.341032891e-03, -4.314988479e-02, 5.820709094e-02, 9.726932272e-03, 9.204921871e-02, -5.461431667e-02, 2.188877203e-02, 7.095082104e-02, -1.986800283e-01, -5.253232270e-02, -2.151457407e-02, 4.009447619e-02, 2.904919162e-02, -2.310756966e-02, 3.400049806e-01, 4.373770207e-02, 2.137293853e-02, 4.490584508e-02, 3.854715033e-03, -7.223858684e-02, 3.698365181e-04, 1.687400788e-01, -2.477144897e-01, -1.791501045e-01, -1.272426080e-02, -7.511303574e-02, -6.668000668e-02, 1.089391783e-01, 1.020426378e-01, -1.478020549e-01};
real  Wlin213[0:34] = {1.637657136e-01, -1.184003875e-01, 2.991355956e-01, 4.164089859e-01, 7.269753516e-02, 1.300761253e-01, -7.692407072e-02, 6.364025921e-02, -1.956878006e-01, 1.299296767e-01, 1.369698495e-01, 5.829440951e-01, 1.036165953e-01, 9.570565820e-02, -5.746813864e-02, -1.931038648e-01, 7.816451043e-02, 2.600286305e-01, 1.166290119e-01, -2.498303726e-02, -1.810974926e-01, -2.243330479e-01, 6.040099636e-02, 8.915699273e-02, 2.459828854e-01, 8.707651496e-02, -8.136518300e-02, -1.865453571e-01, 3.759130239e-01, 2.178177983e-01, -1.748739034e-01, -2.088651657e-01, -2.707179785e-01, 4.675933346e-02, 3.156861663e-01};
real  Wlin214[0:34] = {1.500864029e-01, -1.378231496e-01, -2.342870086e-02, -1.558181942e-01, 2.120498270e-01, -5.040180311e-02, -1.257213801e-01, -1.292511672e-01, 8.460354805e-02, 3.342657909e-02, 1.005746797e-01, 3.825461566e-01, 1.239139661e-01, -1.198214069e-01, -3.198509570e-03, -1.074866056e-01, 7.601900399e-02, -1.529162973e-01, 7.724349946e-02, -4.786252975e-02, -6.323144585e-02, -4.738431871e-01, 2.452337146e-01, 6.118129939e-02, 4.416638613e-02, 2.809383571e-01, -3.141338229e-01, 1.689554006e-01, 8.532550931e-02, -5.730243325e-01, 2.572089434e-01, 8.013264835e-02, -1.776809841e-01, -4.820010066e-02, -1.937870532e-01};
real  Wlin215[0:34] = {-1.831770390e-01, 1.217556149e-01, -1.132423654e-01, -2.944142222e-01, -2.563726008e-01, -3.021468222e-01, -7.528354973e-02, -3.092394618e-04, -2.465213835e-01, 9.233867377e-02, 1.879960112e-02, 5.446971655e-01, -9.218182415e-02, 4.125986621e-02, -2.338383906e-02, 1.353731602e-01, -1.060077175e-01, -1.639079601e-01, 1.177350357e-01, -3.604387343e-01, 4.573847633e-03, -2.645947598e-02, -1.541601121e-01, -9.916768968e-02, -1.891055703e-01, -5.738992617e-02, -1.862903237e-01, -2.036063373e-01, -1.395441592e-01, -3.125848472e-01, 3.281126618e-01, -1.892841160e-01, -3.575564325e-01, 1.227849349e-01, -1.723828614e-01};
real  Wlin216[0:34] = {2.798077464e-01, -2.499106526e-01, 4.779962078e-02, -5.261750147e-02, 1.575344205e-01, 9.151695669e-02, -9.838224202e-02, 1.395181715e-01, -1.102049872e-01, 6.980200857e-02, -1.577651054e-01, -4.325259030e-01, 4.780248925e-02, -7.848332822e-02, 2.537338994e-02, 2.255325615e-01, 5.177954584e-02, 1.848369539e-01, 9.912533313e-02, -2.865489721e-01, 9.607762843e-02, 4.633343965e-02, -1.554421186e-01, 6.843762845e-02, -1.049414510e-03, 1.001502201e-02, -9.691358358e-02, -3.156420588e-01, -2.835979164e-01, 1.610140800e-01, -1.280015917e-03, -1.401436478e-01, 4.097465873e-01, -1.027545035e-01, 1.855687052e-01};
real  Wlin217[0:34] = {-2.471186407e-02, -1.440273970e-01, 3.631027341e-01, -2.270507663e-01, -4.560052417e-03, -1.582883894e-01, 7.758878917e-02, -1.503417343e-01, -1.744653881e-01, 5.116256326e-02, 1.866565347e-01, 2.340044379e-01, -1.685145646e-01, -1.177144144e-02, -1.992115974e-01, -1.075802967e-01, 1.127644703e-01, -1.748306006e-01, 3.211326897e-02, -5.816820636e-02, 3.990520164e-02, -3.485494107e-02, 4.086185247e-02, -8.194249123e-02, 1.983237453e-02, -3.777420148e-02, -2.703708112e-01, -1.071520336e-02, -1.150417030e-01, -1.783628762e-01, 1.542192847e-01, -2.625499479e-02, -3.888356090e-01, 4.797596857e-02, 2.030225843e-01};
real  Wlin218[0:34] = {-9.634831548e-02, 6.029162928e-02, 3.484221697e-01, 1.448970884e-01, -1.537289172e-01, -1.804661751e-01, 3.881622106e-02, -1.402332932e-01, -4.268390834e-01, -2.412175946e-02, 2.386953980e-01, -5.910664201e-01, -2.178754210e-01, -1.718166471e-01, 1.241434067e-01, -4.350138605e-01, -1.950369477e-01, 4.087599739e-02, 5.316568613e-01, 1.330919862e-01, -3.410482779e-02, 3.012453616e-01, 1.388108172e-02, -1.615601480e-01, -1.730815470e-01, -4.065329731e-01, 3.984588683e-01, 9.500434250e-02, 2.945333719e-01, -2.658097818e-02, -3.887251318e-01, -2.785761356e-01, 3.814895079e-02, 1.620484740e-01, 3.398276865e-01};
real  Wlin219[0:34] = {2.760354280e-01, 1.137040704e-01, -2.065973133e-01, 1.039153636e-01, -1.917201728e-01, -3.095854260e-02, -7.879685611e-02, 6.682252884e-02, -1.387701780e-01, 4.471031949e-02, 2.348778099e-01, 6.197349727e-02, 1.725028455e-02, 5.991687253e-02, -5.302824080e-02, 1.202811077e-01, -5.217802525e-02, -1.089170650e-01, 1.873230785e-01, -2.587409019e-01, 4.030161072e-03, -9.817421436e-02, 1.662049443e-01, -3.374031279e-03, -2.882463858e-02, 4.660136998e-03, 1.005241740e-02, 3.176286444e-02, -2.685438693e-01, 3.049319088e-01, 5.584993213e-02, 5.448672920e-03, 2.072290704e-02, 2.050044946e-02, 1.587037295e-01};
real  Wlin220[0:34] = {3.572329134e-02, -1.332870591e-02, -2.854383588e-01, -9.927130491e-02, -1.856719144e-02, 2.534752190e-01, 3.149762924e-04, 2.045402080e-01, -3.430642784e-01, -8.106232435e-02, -3.408695757e-01, 2.849938571e-01, -1.782515198e-01, -3.326322883e-02, -1.226659119e-02, -5.131215453e-01, -1.382320076e-01, -1.675306112e-01, 1.067838073e+00, -2.929691970e-01, -2.118658125e-01, 9.252634645e-02, 9.109555930e-02, -8.477504551e-02, 6.708364934e-02, 3.430302739e-01, 4.209839702e-01, 2.473983318e-01, 3.930075765e-01, -3.249084651e-01, -2.069803625e-01, -4.215909839e-01, -2.111925334e-01, 1.140413880e-01, -3.834291101e-01};
real  Wlin221[0:34] = {6.683599949e-02, -5.234071612e-02, -2.506332397e-01, 1.367910206e-01, 6.077876315e-02, 2.069721818e-01, -1.485577598e-02, -1.341692507e-01, 2.667574026e-02, 1.618844122e-01, -3.415433168e-01, 2.135657817e-01, -1.609161794e-01, -1.116269901e-01, 1.090758890e-01, -5.208895802e-01, 9.433159977e-02, -8.624131978e-02, 8.045656979e-02, -9.709517658e-02, -2.502324581e-01, 9.403781593e-02, 3.093850613e-01, 7.683829218e-02, -7.820122689e-02, 2.738756239e-01, 3.358257711e-01, -9.413909167e-02, 1.708234698e-01, -2.916337252e-01, 1.397267580e-01, -2.939470112e-01, 1.346981376e-01, 1.827250570e-01, 1.774370372e-01};
real  Wlin222[0:34] = {1.737741008e-02, -2.410861254e-01, -1.552901417e-01, 1.244419739e-01, 5.136474967e-02, -2.936867774e-01, -2.342366055e-02, -8.242934942e-02, 1.487191617e-01, 1.918835752e-02, -7.004636526e-02, -8.608456850e-01, -2.869016230e-01, -2.925664373e-02, 7.104243338e-02, -1.039848104e-02, 7.729577366e-03, 1.251207143e-01, -1.624440104e-01, -1.447201967e-01, -6.852285564e-02, 2.294599563e-01, -4.042334259e-01, 9.522672743e-03, 2.693496831e-02, -3.353839219e-01, 1.578078419e-02, -9.150850028e-02, -2.387838438e-02, 3.517235219e-01, 3.074103296e-01, 1.924711019e-01, 7.346401215e-01, 2.057999559e-02, -4.617118090e-02};
real  Wlin223[0:34] = {1.082604304e-01, -6.150514632e-02, -1.768140495e-01, -6.141244620e-02, -1.428431273e-01, 1.172821149e-01, -1.714096516e-01, 5.799100921e-02, 1.284271330e-01, -2.241791598e-02, 3.938497901e-01, 2.689810395e-01, 2.319166958e-01, -3.950651363e-02, -1.188652143e-01, 3.364903331e-01, -5.314273015e-02, 2.344392091e-01, 2.878921628e-01, 4.821301401e-01, -6.501048058e-02, 1.766979694e-01, -2.016120777e-02, 5.387013778e-02, -3.130907565e-02, 1.154893078e-02, 1.647104770e-01, 1.993457079e-01, -9.435425512e-03, 1.501652300e-01, -3.420015052e-02, 1.493694037e-01, -7.848060876e-02, 1.611570269e-01, 1.860337406e-01};
real  Wlin224[0:34] = {6.396834552e-02, 1.517317146e-01, 1.028875411e-01, 7.143183798e-02, 1.300692260e-01, 2.592042685e-01, -4.352337494e-02, -8.288299292e-02, -3.410588205e-01, -1.439484116e-02, -3.396181017e-02, -2.884994745e-01, -4.244718328e-02, -3.307827562e-02, 5.389545858e-02, -2.779945731e-01, 9.895168990e-02, 3.482066691e-01, 1.346898675e-01, -2.599455230e-02, -2.507259846e-01, 2.167912275e-01, 2.541360259e-01, 2.248502150e-02, 1.759062894e-02, -4.126472771e-02, 3.148438036e-01, -2.771404088e-01, -1.204803213e-01, 9.477896243e-02, -3.881777227e-01, 1.795948111e-02, 1.988058835e-01, -1.403625403e-02, -6.649987400e-02};
real  Wlin225[0:34] = {7.377307862e-02, 1.321415305e-01, -2.080188692e-01, 1.195363998e-01, -5.824203417e-02, 5.267071724e-02, -2.748861723e-02, -3.797568008e-02, 4.505928233e-02, 1.317908764e-01, 4.069802761e-01, 1.710313112e-01, 1.577809304e-01, 3.664723411e-02, 1.424896866e-01, -1.801269129e-02, 1.754971892e-01, 3.548355773e-02, 3.164163604e-02, -2.677287720e-02, 5.332841724e-02, -1.583996117e-01, 1.865088791e-01, -2.162347287e-01, 3.148430586e-02, 1.875658333e-02, -1.473140568e-01, -1.283465773e-01, 2.380138934e-01, 2.396043837e-01, -1.068613455e-01, 1.222751439e-01, 6.019881694e-04, -5.689604953e-02, -4.534187168e-02};
real  Wlin226[0:34] = {-8.923484385e-02, 2.089907527e-01, 2.488647997e-01, 7.770144194e-02, -5.851624534e-03, -1.470140517e-01, -1.667975634e-02, 6.435415894e-02, -2.703432143e-01, 1.877166927e-01, 1.730859466e-02, 3.030200899e-01, 2.936603129e-01, 1.484434009e-01, -1.560311317e-01, -1.794426292e-01, -1.034613512e-02, 1.685059816e-01, 1.301791370e-01, -3.506916463e-01, -1.478380412e-01, -2.533805966e-01, 3.396703899e-01, 1.623561233e-01, 5.517297611e-02, 1.202894300e-01, -3.452089801e-02, -2.015553117e-01, 3.100005388e-01, -2.846656144e-01, 2.384069860e-01, 1.081810594e-01, -7.613573223e-02, 2.469355613e-02, 3.479589224e-01};
real  Wlin227[0:34] = {2.124803700e-02, 3.879703283e-01, 3.530398905e-01, 8.889578283e-02, 1.545594484e-01, -2.765023708e-02, 1.059401967e-02, -1.150313616e-01, 3.478699550e-02, 6.539864093e-02, -8.503824472e-02, 1.553975344e-01, 1.523040086e-01, 4.109920934e-02, -7.225877047e-02, -2.261421233e-01, -5.964870378e-02, 5.205523968e-02, -1.039750054e-01, -8.870572597e-02, 2.778075039e-01, -3.634139299e-01, -1.895395964e-01, 9.392152727e-02, 1.374806911e-01, -3.899253309e-01, 1.622070074e-01, -4.378363490e-03, 1.171319112e-01, 5.413482785e-01, -3.627597988e-01, 3.530977070e-01, 1.083023846e-01, -2.447973005e-02, -1.932450235e-01};
real  Wlin228[0:34] = {-2.891595662e-02, -3.778974414e-01, -2.091088565e-03, -7.091101259e-02, 1.493651420e-01, 9.280156344e-02, -4.131586850e-02, -1.442219019e-01, 2.645744383e-01, 7.961542159e-02, 2.023841441e-01, 1.847538948e-01, 2.536383569e-01, 1.875105500e-02, -5.428250507e-02, 1.121569872e-01, -1.537575871e-01, -2.033709735e-01, 2.394699007e-01, 3.244596422e-01, -4.237113595e-01, 2.159695029e-01, 2.556828260e-01, 6.470373273e-02, 1.202614382e-01, 3.315530419e-01, 1.191210598e-01, -9.828956425e-02, -4.130483139e-03, -4.352200925e-01, 2.421365976e-01, -1.842601150e-01, 2.027307451e-01, 4.578050226e-02, -2.502306998e-01};
real  Wlin229[0:34] = {-5.359228700e-02, -4.611816630e-02, 2.516903579e-01, -1.097860113e-01, -6.559280306e-02, -7.179001719e-02, 1.302026212e-01, 4.102220759e-02, -2.596140504e-01, 4.650650918e-02, 2.694210410e-01, 9.383600950e-02, 2.666142583e-01, 7.190828677e-03, -1.720612645e-01, -3.667554557e-01, -7.372309268e-02, 8.674014360e-02, 4.506167769e-01, -1.539565176e-01, -1.205049604e-01, -9.765052050e-02, 3.172570765e-01, 9.129647166e-02, 1.136024445e-01, -6.142426655e-02, 2.350234538e-01, -2.283175103e-02, 5.245236680e-02, 9.141947329e-02, 2.607502043e-02, -1.502353996e-01, 1.378840301e-02, 4.077326506e-02, -9.295187145e-02};
real  Wlin230[0:34] = {7.750563323e-02, -3.790021688e-02, -8.708596975e-02, 2.958704345e-02, -6.058638543e-02, 2.257172614e-01, 2.767869830e-01, 2.851554193e-02, -7.835133001e-03, -1.014366299e-01, 1.617889702e-01, 1.432462633e-01, 2.470544726e-01, -1.183608919e-01, -1.157473624e-01, 2.292031497e-01, 1.552101523e-01, 2.832037210e-01, -1.065445468e-01, 1.512669474e-01, 1.988325734e-03, 1.143607497e-01, -1.553993821e-01, -1.829859614e-01, -1.046398878e-01, 1.578617543e-01, -8.789286017e-02, 2.383981794e-01, 1.252697855e-01, 5.436788127e-02, 1.092862487e-01, -1.972517222e-01, -2.274885774e-02, -1.245886385e-01, -2.457742020e-02};
real  Wlin231[0:34] = {7.834929228e-02, 2.122615129e-01, 2.466885298e-01, 3.432810605e-01, -1.136626229e-01, 3.803702593e-01, -1.081559993e-02, 9.450091980e-03, -2.685437500e-01, 1.317108274e-01, 2.228447646e-01, -2.226628661e-01, 9.632705897e-02, 9.708994627e-02, -1.390599161e-01, -3.343723714e-01, -7.250873744e-02, 7.305368036e-02, 2.930680215e-01, -1.960341185e-01, 9.400341660e-02, 1.565691829e-01, -1.082314476e-01, 4.027716350e-03, -9.175776690e-02, 1.051843092e-01, 1.576009542e-01, 1.527067125e-01, 2.938647270e-01, 2.721119523e-01, -5.233106017e-02, -2.169300430e-02, -7.969333977e-02, 1.060529426e-01, -9.460524470e-02};
real  Wlin232[0:34] = {-1.001516655e-01, 3.694329783e-02, 1.827703267e-01, -9.818585962e-02, -1.006270498e-01, 3.493093848e-01, -1.649820060e-01, -9.675096720e-02, 3.099162877e-01, -3.569705039e-02, 3.381087780e-01, 3.249502778e-01, 4.203519821e-01, -6.575716287e-02, 2.787728906e-01, 2.986566722e-01, -1.425550729e-01, -1.107290015e-01, -2.508584857e-01, -1.808491200e-01, 9.917423129e-02, 1.829836369e-01, 8.267747611e-02, -1.018685251e-01, -4.743974656e-02, 2.511321008e-01, -5.932712927e-02, -1.478580087e-01, -1.331558228e-01, -3.129505217e-01, 6.027380005e-02, 2.035609446e-02, -1.930749714e-01, 1.817473769e-01, 1.848086417e-01};
real  Wlin233[0:34] = {1.038779691e-01, 1.402551830e-01, 4.279787242e-01, -8.551592380e-02, 2.012476772e-01, -2.173163928e-02, 2.316059917e-02, -8.594284952e-02, 1.005898118e-01, 5.456484854e-02, 2.440401316e-01, 2.306603640e-01, 1.530416906e-01, 1.432079226e-01, -8.353196830e-02, 6.211409345e-02, -1.483194828e-01, 2.284053899e-02, -2.548427135e-02, 3.677268326e-01, -9.412958287e-03, 1.391254812e-01, 1.375679821e-01, 6.691026688e-02, -1.376957297e-01, -1.236219406e-01, 2.899028063e-01, 6.583165377e-02, -3.013549149e-01, 1.615178436e-01, 7.770018280e-02, -2.859326079e-02, -9.267823398e-02, 1.712715328e-01, -9.091653675e-02};
real  Wlin234[0:34] = {-1.598378271e-01, -2.275181860e-01, -1.648924053e-01, 2.393404096e-01, -4.633752257e-02, 9.222011268e-02, 2.661580965e-02, -9.929522872e-02, -2.374034226e-01, 3.854822740e-02, -4.481132925e-01, -1.780663580e-01, -3.332889453e-02, -3.624350950e-02, -3.788927197e-02, -4.306896776e-02, 2.280309498e-01, 1.821731962e-02, 1.929190010e-02, 3.030467629e-01, -1.447830647e-01, 2.501750290e-01, 3.246068656e-01, -4.909970611e-02, 9.863199294e-02, 1.045557335e-01, -3.301120698e-01, -6.486245990e-02, -1.182137951e-01, 2.488933504e-01, -1.450829953e-01, 1.564644426e-01, 2.616728246e-01, -1.473657042e-01, 2.178811282e-01};

real  Blin2[0:34] = {-4.117382318e-02, 1.606452763e-01, 1.256579608e-01, 2.743720710e-01, 3.662115708e-02, -9.356333315e-02, -3.373370320e-02, 1.016181260e-01, -3.059960604e-01, -4.746346921e-02, 9.236243367e-02, -1.974912733e-01, -1.371855289e-01, 1.635862887e-02, 4.176510498e-02, -2.254980654e-01, 7.644028962e-02, 2.021921724e-01, 3.027256429e-01, 1.213891059e-01, 5.764224753e-02, 1.486016959e-01, 5.425729230e-02, 5.675335706e-05, 5.156339705e-02, -1.249451283e-02, 3.173154294e-01, 4.325705115e-03, -4.041354731e-02, -1.407322567e-02, -2.585379779e-01, -6.042962894e-02, 1.337163448e-01, -9.230840206e-02, 1.693436801e-01};
// --- OutputLayer ---
real  Wlin30[0:0] = {5.954551307e-05};
real  Wlin31[0:0] = {8.671620488e-02};
real  Wlin32[0:0] = {5.246508867e-02};
real  Wlin33[0:0] = {2.197879851e-01};
real  Wlin34[0:0] = {1.266515756e-04};
real  Wlin35[0:0] = {-1.752415150e-01};
real  Wlin36[0:0] = {9.327259031e-04};
real  Wlin37[0:0] = {6.585542578e-04};
real  Wlin38[0:0] = {-1.678104103e-01};
real  Wlin39[0:0] = {-2.700684418e-04};
real  Wlin310[0:0] = {4.234709963e-02};
real  Wlin311[0:0] = {9.905683994e-02};
real  Wlin312[0:0] = {-1.451020241e-01};
real  Wlin313[0:0] = {4.032361030e-04};
real  Wlin314[0:0] = {-1.219496364e-03};
real  Wlin315[0:0] = {2.559868991e-01};
real  Wlin316[0:0] = {-9.469412616e-04};
real  Wlin317[0:0] = {7.787453383e-02};
real  Wlin318[0:0] = {-2.426669747e-01};
real  Wlin319[0:0] = {9.898137301e-03};
real  Wlin320[0:0] = {2.049134523e-01};
real  Wlin321[0:0] = {1.117369458e-01};
real  Wlin322[0:0] = {-8.675102144e-02};
real  Wlin323[0:0] = {-2.037348168e-04};
real  Wlin324[0:0] = {1.926656230e-03};
real  Wlin325[0:0] = {2.490748167e-01};
real  Wlin326[0:0] = {1.157480553e-01};
real  Wlin327[0:0] = {-3.517435689e-04};
real  Wlin328[0:0] = {-5.417846143e-02};
real  Wlin329[0:0] = {-2.331755497e-02};
real  Wlin330[0:0] = {-1.838525385e-01};
real  Wlin331[0:0] = {1.952012628e-01};
real  Wlin332[0:0] = {1.340312809e-01};
real  Wlin333[0:0] = {3.104177595e-04};
real  Wlin334[0:0] = {-4.159698146e-04};

real  Blin3[0:0] = {1.347927451e-01};
// --- Backend params ---
real  offset = 8;
real slope = 4;
real epsilon = 1E-100;

// --- variables ---
real Qfg,Qtg,Qbg,Qlat1,Qlat2;
real Ilat12;
real Layer0_out [0:60];
real Layer1_out [0:60];
real Layer2_out [0:60];
real Layerlin0_out [0:60];
real Layerlin1_out [0:60];
real Layerlin2_out [0:60];
real sigma_log;
real Ilat1_log,Ilat1_lin,out;
real volt[0:3];
real neuron_of_L_0;
real neuron_of_L_1;
real neuron_of_L_2;
real neuron_of_L_3;
real neuronlin_of_L0;
real neuronlin_of_L1;
real neuronlin_of_L2;
real neuronlin_of_L3;
real beta;
real k;
real Qscale;

branch (lat2,lat1) b_lat21;
branch (FG,lat1) b_FG1;
branch (TG,lat1) b_TG1;
branch (BG,lat1) b_BG1;

//--- iteratzion variables required in for-loops ---
genvar j;

analog begin

volt[0] = V(b_lat21);
volt[1] = V(b_FG1);
volt[2] = V(b_TG1);
volt[3] = V(b_BG1);

 // I MODEL

// --- loops ---
// --- HiddenLayer1 ---
for (j=0;j<34;j=j+1) begin
neuron_of_L_0 = W00[j]*volt[0] + W01[j]*volt[1] + W02[j]*volt[2] + B0[j];
Layer0_out[j] = tanh(neuron_of_L_0);
end
// --- HiddenLayer2 ---
for (j=0;j<34;j=j+1) begin
neuron_of_L_1 = W10[j]*Layer0_out[0] + W11[j]*Layer0_out[1] + W12[j]*Layer0_out[2] + W13[j]*Layer0_out[3] + W14[j]*Layer0_out[4] + W15[j]*Layer0_out[5] + W16[j]*Layer0_out[6] + W17[j]*Layer0_out[7] + W18[j]*Layer0_out[8] + W19[j]*Layer0_out[9] + W110[j]*Layer0_out[10] + W111[j]*Layer0_out[11] + W112[j]*Layer0_out[12] + W113[j]*Layer0_out[13] + W114[j]*Layer0_out[14] + W115[j]*Layer0_out[15] + W116[j]*Layer0_out[16] + W117[j]*Layer0_out[17] + W118[j]*Layer0_out[18] + W119[j]*Layer0_out[19] + W120[j]*Layer0_out[20] + W121[j]*Layer0_out[21] + W122[j]*Layer0_out[22] + W123[j]*Layer0_out[23] + W124[j]*Layer0_out[24] + W125[j]*Layer0_out[25] + W126[j]*Layer0_out[26] + W127[j]*Layer0_out[27] + W128[j]*Layer0_out[28] + W129[j]*Layer0_out[29] + W130[j]*Layer0_out[30] + W131[j]*Layer0_out[31] + W132[j]*Layer0_out[32] + W133[j]*Layer0_out[33] + B1[j];
Layer1_out[j] = tanh(neuron_of_L_1);
end
// --- HiddenLayer3 ---
for (j=0;j<34;j=j+1) begin
neuron_of_L_2 = W20[j]*Layer1_out[0] + W21[j]*Layer1_out[1] + W22[j]*Layer1_out[2] + W23[j]*Layer1_out[3] + W24[j]*Layer1_out[4] + W25[j]*Layer1_out[5] + W26[j]*Layer1_out[6] + W27[j]*Layer1_out[7] + W28[j]*Layer1_out[8] + W29[j]*Layer1_out[9] + W210[j]*Layer1_out[10] + W211[j]*Layer1_out[11] + W212[j]*Layer1_out[12] + W213[j]*Layer1_out[13] + W214[j]*Layer1_out[14] + W215[j]*Layer1_out[15] + W216[j]*Layer1_out[16] + W217[j]*Layer1_out[17] + W218[j]*Layer1_out[18] + W219[j]*Layer1_out[19] + W220[j]*Layer1_out[20] + W221[j]*Layer1_out[21] + W222[j]*Layer1_out[22] + W223[j]*Layer1_out[23] + W224[j]*Layer1_out[24] + W225[j]*Layer1_out[25] + W226[j]*Layer1_out[26] + W227[j]*Layer1_out[27] + W228[j]*Layer1_out[28] + W229[j]*Layer1_out[29] + W230[j]*Layer1_out[30] + W231[j]*Layer1_out[31] + W232[j]*Layer1_out[32] + W233[j]*Layer1_out[33] + B2[j];
Layer2_out[j] = tanh(neuron_of_L_2);
end
// --- OutputLayer ---
for (j=0;j<1;j=j+1) begin
neuron_of_L_3 = W30[j]*Layer2_out[0] + W31[j]*Layer2_out[1] + W32[j]*Layer2_out[2] + W33[j]*Layer2_out[3] + W34[j]*Layer2_out[4] + W35[j]*Layer2_out[5] + W36[j]*Layer2_out[6] + W37[j]*Layer2_out[7] + W38[j]*Layer2_out[8] + W39[j]*Layer2_out[9] + W310[j]*Layer2_out[10] + W311[j]*Layer2_out[11] + W312[j]*Layer2_out[12] + W313[j]*Layer2_out[13] + W314[j]*Layer2_out[14] + W315[j]*Layer2_out[15] + W316[j]*Layer2_out[16] + W317[j]*Layer2_out[17] + W318[j]*Layer2_out[18] + W319[j]*Layer2_out[19] + W320[j]*Layer2_out[20] + W321[j]*Layer2_out[21] + W322[j]*Layer2_out[22] + W323[j]*Layer2_out[23] + W324[j]*Layer2_out[24] + W325[j]*Layer2_out[25] + W326[j]*Layer2_out[26] + W327[j]*Layer2_out[27] + W328[j]*Layer2_out[28] + W329[j]*Layer2_out[29] + W330[j]*Layer2_out[30] + W331[j]*Layer2_out[31] + W332[j]*Layer2_out[32] + W333[j]*Layer2_out[33] + B3[j];
sigma_log = neuron_of_L_3;
end
//--- Backtransfer ---
Ilat1_log = volt[0] *(-1)*exp(sigma_log * 1) ;

// --- loops ---
// --- HiddenLayer1 ---
for (j=0;j<35;j=j+1) begin
neuronlin_of_L0 = Wlin00[j]*volt[0] + Wlin01[j]*volt[1] + Wlin02[j]*volt[2] + Blin0[j];
Layerlin0_out[j] = tanh(neuronlin_of_L0);
end
// --- HiddenLayer2 ---
for (j=0;j<35;j=j+1) begin
neuronlin_of_L1 = Wlin10[j]*Layerlin0_out[0] + Wlin11[j]*Layerlin0_out[1] + Wlin12[j]*Layerlin0_out[2] + Wlin13[j]*Layerlin0_out[3] + Wlin14[j]*Layerlin0_out[4] + Wlin15[j]*Layerlin0_out[5] + Wlin16[j]*Layerlin0_out[6] + Wlin17[j]*Layerlin0_out[7] + Wlin18[j]*Layerlin0_out[8] + Wlin19[j]*Layerlin0_out[9] + Wlin110[j]*Layerlin0_out[10] + Wlin111[j]*Layerlin0_out[11] + Wlin112[j]*Layerlin0_out[12] + Wlin113[j]*Layerlin0_out[13] + Wlin114[j]*Layerlin0_out[14] + Wlin115[j]*Layerlin0_out[15] + Wlin116[j]*Layerlin0_out[16] + Wlin117[j]*Layerlin0_out[17] + Wlin118[j]*Layerlin0_out[18] + Wlin119[j]*Layerlin0_out[19] + Wlin120[j]*Layerlin0_out[20] + Wlin121[j]*Layerlin0_out[21] + Wlin122[j]*Layerlin0_out[22] + Wlin123[j]*Layerlin0_out[23] + Wlin124[j]*Layerlin0_out[24] + Wlin125[j]*Layerlin0_out[25] + Wlin126[j]*Layerlin0_out[26] + Wlin127[j]*Layerlin0_out[27] + Wlin128[j]*Layerlin0_out[28] + Wlin129[j]*Layerlin0_out[29] + Wlin130[j]*Layerlin0_out[30] + Wlin131[j]*Layerlin0_out[31] + Wlin132[j]*Layerlin0_out[32] + Wlin133[j]*Layerlin0_out[33] + Wlin134[j]*Layerlin0_out[34] + Blin1[j];
Layerlin1_out[j] = tanh(neuronlin_of_L1);
end
// --- HiddenLayer3 ---
for (j=0;j<35;j=j+1) begin
neuronlin_of_L2 = Wlin20[j]*Layerlin1_out[0] + Wlin21[j]*Layerlin1_out[1] + Wlin22[j]*Layerlin1_out[2] + Wlin23[j]*Layerlin1_out[3] + Wlin24[j]*Layerlin1_out[4] + Wlin25[j]*Layerlin1_out[5] + Wlin26[j]*Layerlin1_out[6] + Wlin27[j]*Layerlin1_out[7] + Wlin28[j]*Layerlin1_out[8] + Wlin29[j]*Layerlin1_out[9] + Wlin210[j]*Layerlin1_out[10] + Wlin211[j]*Layerlin1_out[11] + Wlin212[j]*Layerlin1_out[12] + Wlin213[j]*Layerlin1_out[13] + Wlin214[j]*Layerlin1_out[14] + Wlin215[j]*Layerlin1_out[15] + Wlin216[j]*Layerlin1_out[16] + Wlin217[j]*Layerlin1_out[17] + Wlin218[j]*Layerlin1_out[18] + Wlin219[j]*Layerlin1_out[19] + Wlin220[j]*Layerlin1_out[20] + Wlin221[j]*Layerlin1_out[21] + Wlin222[j]*Layerlin1_out[22] + Wlin223[j]*Layerlin1_out[23] + Wlin224[j]*Layerlin1_out[24] + Wlin225[j]*Layerlin1_out[25] + Wlin226[j]*Layerlin1_out[26] + Wlin227[j]*Layerlin1_out[27] + Wlin228[j]*Layerlin1_out[28] + Wlin229[j]*Layerlin1_out[29] + Wlin230[j]*Layerlin1_out[30] + Wlin231[j]*Layerlin1_out[31] + Wlin232[j]*Layerlin1_out[32] + Wlin233[j]*Layerlin1_out[33] + Wlin234[j]*Layerlin1_out[34] + Blin2[j];
Layerlin2_out[j] = tanh(neuronlin_of_L2);
end
// --- OutputLayer ---
for (j=0;j<1;j=j+1) begin
neuronlin_of_L3 = Wlin30[j]*Layerlin2_out[0] + Wlin31[j]*Layerlin2_out[1] + Wlin32[j]*Layerlin2_out[2] + Wlin33[j]*Layerlin2_out[3] + Wlin34[j]*Layerlin2_out[4] + Wlin35[j]*Layerlin2_out[5] + Wlin36[j]*Layerlin2_out[6] + Wlin37[j]*Layerlin2_out[7] + Wlin38[j]*Layerlin2_out[8] + Wlin39[j]*Layerlin2_out[9] + Wlin310[j]*Layerlin2_out[10] + Wlin311[j]*Layerlin2_out[11] + Wlin312[j]*Layerlin2_out[12] + Wlin313[j]*Layerlin2_out[13] + Wlin314[j]*Layerlin2_out[14] + Wlin315[j]*Layerlin2_out[15] + Wlin316[j]*Layerlin2_out[16] + Wlin317[j]*Layerlin2_out[17] + Wlin318[j]*Layerlin2_out[18] + Wlin319[j]*Layerlin2_out[19] + Wlin320[j]*Layerlin2_out[20] + Wlin321[j]*Layerlin2_out[21] + Wlin322[j]*Layerlin2_out[22] + Wlin323[j]*Layerlin2_out[23] + Wlin324[j]*Layerlin2_out[24] + Wlin325[j]*Layerlin2_out[25] + Wlin326[j]*Layerlin2_out[26] + Wlin327[j]*Layerlin2_out[27] + Wlin328[j]*Layerlin2_out[28] + Wlin329[j]*Layerlin2_out[29] + Wlin330[j]*Layerlin2_out[30] + Wlin331[j]*Layerlin2_out[31] + Wlin332[j]*Layerlin2_out[32] + Wlin333[j]*Layerlin2_out[33] + Wlin334[j]*Layerlin2_out[34] + Blin3[j];
Ilat1_lin = neuronlin_of_L3;
end
// --- ensembeling backed (tanh)---
k = 0.5*log((Ilat1_log**2)+epsilon);
beta = 0.5*(1+tanh(slope*k+offset));
out = beta* Ilat1_lin * 1.0 + (1-beta)*Ilat1_log;

//$strobe("sigma_log: %f, volt0= %f, out=%f", sigma_log, volt[0], out);

 // Q MODEL
Qscale = 1e-15;

Qbg = -0.246520388583*V(b_lat21) + 0.484817871446 - 0.400264940098*exp(-2.0*(exp(-1.65196777675*(0.28108830241*V(b_TG1) - 1)**2 - 1.86056253603*(0.304893186579*V(b_TG1) - 1)**2*(0.672089299337*V(b_lat21) + 0.764567917695*V(b_TG1) + 1)**2) + exp(-0.13882299225*(0.948881830408*V(b_lat21) - 0.326058231763*V(b_TG1) - 1)**2 - 2.0*exp(-0.612928140495*(0.263976176594*V(b_lat21) + 1)**2 - 27.7317555124*(0.379788066372*(0.65192923073 - 0.310353258838*V(b_FG1))*(1.30316628332 - 0.0795294485979*V(b_TG1)) - exp(-1.4717956973*(0.00334650804996*V(b_TG1) - 1)**2 - 2.0*exp(-1.3064935659*(1 - 0.37667635846*V(b_lat21))**2)) + 0.0205337136139)**2)))**2);
Qtg = -11.6413999871*(0.153662154924*V(b_lat21) + 1.34114548558)*exp(-2.0*exp(-1.03314841477*(1 - 0.264495502325*V(b_TG1))**2 - 0.307132444273*(0.00494681315807*V(b_FG1) + 1)**2*exp(2*exp(-0.468052956543*(0.442307259193*V(b_TG1) + 1)**2 - 2.0*exp(-0.662829474992*(-V(b_TG1) - 0.626549371973)**2 - 4.0*exp(-6.10423366713*(-V(b_lat21) - 0.263839115104)**2*(0.480439082988*V(b_lat21) + 1)**2 - 5.35225775965*(-0.00529672001149*V(b_FG1) + 0.667004045642*V(b_lat21) + 1)**2))))/((0.00513197100836*V(b_lat21) - 1)**2 + 0.346820348945*exp(-4.50035045328*(-0.576753821565*V(b_lat21) - 1)**2))**2)) + 9.84332151026;
Qfg = 0.233079527084*V(b_TG1) - 2.4096917901*(1.29631725764*V(b_lat21) + (-0.144775919062*V(b_FG1) - 0.986010796273)*(0.914170156517*V(b_FG1) + 0.928274227847)*(0.327982781723*V(b_FG1) - 0.215683109066*V(b_TG1) + 3.1441393011) - 0.302782375694)*exp(-2.0*exp(-0.585917319893*(0.151347056275*V(b_lat21) - 1)**2 - 1.96733710306*(0.467459790393*V(b_lat21) + 1)**2*(0.0744310255106*V(b_TG1) + tanh(0.778231425025*V(b_FG1) + 0.41286888891) - 0.948142754056)**2) - 2.0*exp(-4.0*tanh(tanh(0.0847238305508*V(b_TG1) + 0.75009644551))**2)) - 2.31485764104;
Qlat1 = 3.84831200395*(-0.0575033542052*V(b_FG1) + 0.13498402553*V(b_lat21) - 0.835145285449)*exp(0.203743385932*V(b_FG1) - 0.126069635228*(-0.698851516896*(0.0321860580263*V(b_FG1) + 1)**2*(-0.767321453561*V(b_FG1) + 0.585060937651*V(b_lat21) + exp(-6.86458274819*(-0.478475118576*V(b_lat21) - 1)**2 - 0.72159824109*(V(b_lat21) - 0.13200229275)**2) + 0.730677400493)**2 + 1)**2) + 8.25689838835*exp(-2.0*exp(-0.00395579848488*(-V(b_FG1) - 0.532280107186)**2*(0.692328932507*V(b_TG1) - 1)**2 - 0.924671988032*(0.225180088446*V(b_TG1) - 1)**2) - 2.0*exp(-3.02630159261*(-V(b_FG1) - 0.133901924074)**2 - 4.0*exp(-0.777744679315*(V(b_FG1) - 0.0252511322974)**2 - 0.00510721042549*(-0.400797684542*V(b_lat21) - 1)**2))) - 0.772007163459;
Qlat2 = 4.53678349056*(-0.237024492998*V(b_FG1) + 0.453694129067*V(b_lat21) - 0.477261949639)*exp(-0.0585929055033*V(b_FG1) - 0.308066300577*(-0.339447594101*(0.153381488569*V(b_FG1) + 1)**2*(-0.867035494271*V(b_FG1) + 0.506779330011*V(b_lat21) + exp(-7.42256526474*(-0.479125021514*V(b_lat21) - 1)**2 - 0.520906607656*(V(b_lat21) + 0.0861867476746)**2) + 0.412311896805)**2 + 1)**2) + 7.47059671583*exp(-2.0*exp(-0.000174660505969*(-V(b_FG1) - 0.575507587904)**2*(V(b_TG1) + 0.729503280907)**2 - 1.16717575794*(0.246225581144*V(b_TG1) - 1)**2) - 2.0*exp(-2.90807769523*(-V(b_FG1) - 0.139542242435)**2 - 4.0*exp(-0.991962923103*(V(b_FG1) + 0.048083900553)**2 - 0.244264802718*(0.0234237562543*V(b_lat21) - 1)**2))) - 1.96441798694;

Ilat12 = out /1000;

I(lat1,lat2) <+ Ilat12 ;

I(FG)<+ ddt(Qfg * Qscale);
I(TG)<+ ddt(Qtg* Qscale);
I(BG)<+ ddt(Qbg* Qscale);
I(lat1)<+ ddt(Qlat1* Qscale);
I(lat2)<+ ddt(Qlat2* Qscale);

end

endmodule

// model parameters:

/*{'lin': {'_id': ObjectId('668be66a869e40640bb7941d'), 'data_type': 'DC', 'data_path': '/private/maxr/projects/pytaurus/helper/export/run_regular_grid_common_goal/run_regular_grid_common_goal_lat2_minstep0.02_export.pkl', 'save_path': 'NN_models/mx/lin/', 'mdl_type': 'lin', 'mdl_arch': 'NN', 'augmentation_type': None, 'train_test_split_random_seed': 0, 'tf_epochs': 500, 'tf_es_patience': 400, 'tf_es_delta': 1e-07, 'tf_n_neurons': 35, 'user': 'maxr', 'comment': 'minimal example test', 'lin_prescale': 1}, 'log': {'_id': ObjectId('668be6e5869e40640bb7941e'), 'data_type': 'DC', 'data_path': '/private/maxr/projects/pytaurus/helper/export/run_regular_grid_common_goal/run_regular_grid_common_goal_lat2_minstep0.02_export.pkl', 'save_path': 'NN_models/mx/log/', 'mdl_type': 'log', 'mdl_arch': 'NN', 'augmentation_type': None, 'train_test_split_random_seed': 0, 'tf_epochs': 500, 'tf_es_patience': 400, 'tf_es_delta': 1e-07, 'tf_n_neurons': 34, 'user': 'maxr', 'comment': 'minimal example test'}}

{'_id': ObjectId('668be7cf9144e1dfe0885701'), 'data_type': 'DC', 'data_path': '/private/maxr/projects/pytaurus/helper/export/run_regular_grid_common_goal/run_regular_grid_common_goal_lat2_minstep0.02_export.pkl', 'save_path': 'Qlattice/models/mx', 'mdl_type': 'Q', 'mdl_arch': 'SR', 'augmentation_type': None, 'sr_num_epochs': 2, 'sr_max_complexity': 50, 'sr_train_size': 0.765, 'sr_transfer': None, 'user': 'maxr', 'comment': 'minimal example test'}*/
